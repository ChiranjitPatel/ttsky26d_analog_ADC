* M1 post-layout: op on the rc netlist (generated by sim/m1/make_tb.py), tt, 27 C, 1.8 V
.lib /usr/local/share/pdk/sky130A/libs.tech/ngspice/sky130.lib.spice tt
.include /home/user/ttsky26d_analog_ADC/sim/out/layout/m1_rc/m1_rc.spice
.temp 27
.options reltol=1e-5 abstol=1e-12 vntol=1e-7 chgtol=1e-16
xdut 0 0 0 nc_ua_0_ pad nc_ua_2_ nc_ua_3_ nc_ua_4_ nc_ua_5_ nc_ua_6_ nc_ua_7_ 0 oe 0 bgpd 0 0 0 0 0 0 0 rs 0 0 0 0 nc_uio_oe_0_ nc_uio_oe_1_ nc_uio_oe_2_ nc_uio_oe_3_ nc_uio_oe_4_ nc_uio_oe_5_ nc_uio_oe_6_ nc_uio_oe_7_ nc_uio_out_0_ nc_uio_out_1_ nc_uio_out_2_ nc_uio_out_3_ nc_uio_out_4_ nc_uio_out_5_ nc_uio_out_6_ nc_uio_out_7_ nc_uo_out_0_ nc_uo_out_1_ nc_uo_out_2_ nc_uo_out_3_ nc_uo_out_4_ nc_uo_out_5_ nc_uo_out_6_ nc_uo_out_7_ vdd 0 tt_um_chiranjitpatel_sar_adc
CPAD pad 0 5p
RPAD pad pin 500
CDMM pin 0 10p
RDMM pin 0 10meg
* unused pins (other analog pads, VGND-tied outputs): 1 GOhm to ground so they are not floating
Rnc_ua_0_ nc_ua_0_ 0 1g
Rnc_ua_2_ nc_ua_2_ 0 1g
Rnc_ua_3_ nc_ua_3_ 0 1g
Rnc_ua_4_ nc_ua_4_ 0 1g
Rnc_ua_5_ nc_ua_5_ 0 1g
Rnc_ua_6_ nc_ua_6_ 0 1g
Rnc_ua_7_ nc_ua_7_ 0 1g
Rnc_uio_oe_0_ nc_uio_oe_0_ 0 1g
Rnc_uio_oe_1_ nc_uio_oe_1_ 0 1g
Rnc_uio_oe_2_ nc_uio_oe_2_ 0 1g
Rnc_uio_oe_3_ nc_uio_oe_3_ 0 1g
Rnc_uio_oe_4_ nc_uio_oe_4_ 0 1g
Rnc_uio_oe_5_ nc_uio_oe_5_ 0 1g
Rnc_uio_oe_6_ nc_uio_oe_6_ 0 1g
Rnc_uio_oe_7_ nc_uio_oe_7_ 0 1g
Rnc_uio_out_0_ nc_uio_out_0_ 0 1g
Rnc_uio_out_1_ nc_uio_out_1_ 0 1g
Rnc_uio_out_2_ nc_uio_out_2_ 0 1g
Rnc_uio_out_3_ nc_uio_out_3_ 0 1g
Rnc_uio_out_4_ nc_uio_out_4_ 0 1g
Rnc_uio_out_5_ nc_uio_out_5_ 0 1g
Rnc_uio_out_6_ nc_uio_out_6_ 0 1g
Rnc_uio_out_7_ nc_uio_out_7_ 0 1g
Rnc_uo_out_0_ nc_uo_out_0_ 0 1g
Rnc_uo_out_1_ nc_uo_out_1_ 0 1g
Rnc_uo_out_2_ nc_uo_out_2_ 0 1g
Rnc_uo_out_3_ nc_uo_out_3_ 0 1g
Rnc_uo_out_4_ nc_uo_out_4_ 0 1g
Rnc_uo_out_5_ nc_uo_out_5_ 0 1g
Rnc_uo_out_6_ nc_uo_out_6_ 0 1g
Rnc_uo_out_7_ nc_uo_out_7_ 0 1g
VDD vdd 0 1.8
VPD bgpd 0 0
VOE oe 0 0
VRS rs 0 0
VEXT ext 0 1.5
SEXT ext pin rs 0 swx
.model swx sw vt=0.9 vh=0.1 ron=1 roff=1e15
.control
set wr_singlescale
set wr_vecnames
alter VPD dc=0
alter VOE dc=0
alter VRS dc=0
op
echo RES A_internal vbg $&v(xdut.bandgap_core_0.vbg) vbg_f $&v(xdut.vref_filt_0.vbg_f) vref $&v(xdut.vref_sel_0.vref) vptat $&v(xdut.ptat_out_0.vptat) pin $&v(pin) idd $&i(VDD)
alter VPD dc=0
alter VOE dc=1.8
alter VRS dc=0
op
echo RES B_dmm vbg $&v(xdut.bandgap_core_0.vbg) vbg_f $&v(xdut.vref_filt_0.vbg_f) vref $&v(xdut.vref_sel_0.vref) vptat $&v(xdut.ptat_out_0.vptat) pin $&v(pin) idd $&i(VDD)
alter VPD dc=0
alter VOE dc=0
alter VRS dc=1.8
op
echo RES C_extref vbg $&v(xdut.bandgap_core_0.vbg) vbg_f $&v(xdut.vref_filt_0.vbg_f) vref $&v(xdut.vref_sel_0.vref) vptat $&v(xdut.ptat_out_0.vptat) pin $&v(pin) idd $&i(VDD)
alter VPD dc=1.8
alter VOE dc=0
alter VRS dc=0
op
echo RES D_bgpd vbg $&v(xdut.bandgap_core_0.vbg) vbg_f $&v(xdut.vref_filt_0.vbg_f) vref $&v(xdut.vref_sel_0.vref) vptat $&v(xdut.ptat_out_0.vptat) pin $&v(pin) idd $&i(VDD)
quit
.endc
.end
