* M1 post-layout: ac on the sch netlist (generated by sim/m1/make_tb.py), tt, 27 C, 1.8 V
.lib /usr/local/share/pdk/sky130A/libs.tech/ngspice/sky130.lib.spice tt
.include /home/user/ttsky26d_analog_ADC/layout/cells/m1_top_ref.spice
.temp 27
.options reltol=1e-5 abstol=1e-12 vntol=1e-7 chgtol=1e-16
xdut vdd 0 bgpd oe rs pad tt_um_chiranjitpatel_sar_adc
CPAD pad 0 5p
RPAD pad pin 500
CDMM pin 0 10p
RDMM pin 0 10meg
* unused pins (other analog pads, VGND-tied outputs): 1 GOhm to ground so they are not floating
VDD vdd 0 dc 1.8 ac 1
VPD bgpd 0 0
VOE oe 0 0
VRS rs 0 0
.control
set wr_singlescale
set wr_vecnames
ac dec 20 1 1e8
let p_vbg = -db(v(xdut.vbg))
let p_f = -db(v(xdut.vbg_f))
let p_ref = -db(v(xdut.vref))
wrdata ../out/m1/sch_ac.dat p_vbg p_f p_ref
meas ac pf_dc find p_f at=1
meas ac pf_1m find p_f at=1e6
meas ac pr_dc find p_ref at=1
meas ac pr_1m find p_ref at=1e6
echo RES psrr vbg_f_dc $&pf_dc vbg_f_1m $&pf_1m vref_dc $&pr_dc vref_1m $&pr_1m
quit
.endc
.end
