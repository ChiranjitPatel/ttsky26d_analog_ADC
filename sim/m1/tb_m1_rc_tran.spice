* M1 post-layout: tran on the rc netlist (generated by sim/m1/make_tb.py), tt, 27 C, 1.8 V
.lib /usr/local/share/pdk/sky130A/libs.tech/ngspice/sky130.lib.spice tt
.include /home/user/ttsky26d_analog_ADC/sim/out/layout/m1_rc/m1_rc.spice
.temp 27
.options reltol=1e-4 abstol=1e-12 vntol=1e-6 method=gear
xdut 0 0 0 nc_ua_0_ pad nc_ua_2_ nc_ua_3_ nc_ua_4_ nc_ua_5_ nc_ua_6_ nc_ua_7_ 0 oe 0 bgpd 0 0 0 0 0 0 0 rs 0 0 0 0 nc_uio_oe_0_ nc_uio_oe_1_ nc_uio_oe_2_ nc_uio_oe_3_ nc_uio_oe_4_ nc_uio_oe_5_ nc_uio_oe_6_ nc_uio_oe_7_ nc_uio_out_0_ nc_uio_out_1_ nc_uio_out_2_ nc_uio_out_3_ nc_uio_out_4_ nc_uio_out_5_ nc_uio_out_6_ nc_uio_out_7_ nc_uo_out_0_ nc_uo_out_1_ nc_uo_out_2_ nc_uo_out_3_ nc_uo_out_4_ nc_uo_out_5_ nc_uo_out_6_ nc_uo_out_7_ vdd 0 tt_um_chiranjitpatel_sar_adc
CPAD pad 0 5p
RPAD pad pin 500
CDMM pin 0 10p
RDMM pin 0 10meg
* unused pins (other analog pads, VGND-tied outputs): 1 GOhm to ground so they are not floating
Rnc_ua_0_ nc_ua_0_ 0 1g
Rnc_ua_2_ nc_ua_2_ 0 1g
Rnc_ua_3_ nc_ua_3_ 0 1g
Rnc_ua_4_ nc_ua_4_ 0 1g
Rnc_ua_5_ nc_ua_5_ 0 1g
Rnc_ua_6_ nc_ua_6_ 0 1g
Rnc_ua_7_ nc_ua_7_ 0 1g
Rnc_uio_oe_0_ nc_uio_oe_0_ 0 1g
Rnc_uio_oe_1_ nc_uio_oe_1_ 0 1g
Rnc_uio_oe_2_ nc_uio_oe_2_ 0 1g
Rnc_uio_oe_3_ nc_uio_oe_3_ 0 1g
Rnc_uio_oe_4_ nc_uio_oe_4_ 0 1g
Rnc_uio_oe_5_ nc_uio_oe_5_ 0 1g
Rnc_uio_oe_6_ nc_uio_oe_6_ 0 1g
Rnc_uio_oe_7_ nc_uio_oe_7_ 0 1g
Rnc_uio_out_0_ nc_uio_out_0_ 0 1g
Rnc_uio_out_1_ nc_uio_out_1_ 0 1g
Rnc_uio_out_2_ nc_uio_out_2_ 0 1g
Rnc_uio_out_3_ nc_uio_out_3_ 0 1g
Rnc_uio_out_4_ nc_uio_out_4_ 0 1g
Rnc_uio_out_5_ nc_uio_out_5_ 0 1g
Rnc_uio_out_6_ nc_uio_out_6_ 0 1g
Rnc_uio_out_7_ nc_uio_out_7_ 0 1g
Rnc_uo_out_0_ nc_uo_out_0_ 0 1g
Rnc_uo_out_1_ nc_uo_out_1_ 0 1g
Rnc_uo_out_2_ nc_uo_out_2_ 0 1g
Rnc_uo_out_3_ nc_uo_out_3_ 0 1g
Rnc_uo_out_4_ nc_uo_out_4_ 0 1g
Rnc_uo_out_5_ nc_uo_out_5_ 0 1g
Rnc_uo_out_6_ nc_uo_out_6_ 0 1g
Rnc_uo_out_7_ nc_uo_out_7_ 0 1g
VDD vdd 0 dc 0 pulse(0 1.8 0 1u 1u 1 2)
VOE oe 0 dc 0 pulse(0 1.8 150u 10n 10n 1 2)
VPD bgpd 0 dc 0 pulse(0 1.8 250u 10n 10n 50u 1)
VRS rs 0 0
.control
set wr_singlescale
set wr_vecnames
save v(xdut.bandgap_core_0.vbg) v(xdut.vref_filt_0.vbg_f) v(xdut.vref_sel_0.vref) v(xdut.ptat_out_0.vptat) v(pin) i(VDD)
tran 50n 450u uic
wrdata ../out/m1/rc_tran.dat v(xdut.bandgap_core_0.vbg) v(xdut.vref_filt_0.vbg_f) v(xdut.vref_sel_0.vref) v(xdut.ptat_out_0.vptat) v(pin)
meas tran vref_end find v(xdut.vref_sel_0.vref) at=149u
meas tran t_up when v(xdut.vref_sel_0.vref)=0.99*vref_end rise=1
meas tran pin_end find v(pin) at=249u
meas tran vref_pd find v(xdut.vref_sel_0.vref) at=299u
meas tran idd_pd find i(VDD) at=299u
meas tran vref_re find v(xdut.vref_sel_0.vref) at=449u
meas tran t_re when v(xdut.vref_sel_0.vref)=0.99*vref_re rise=last
echo RES tran vref_end $&vref_end t_up $&t_up pin_end $&pin_end vref_pd $&vref_pd idd_pd $&idd_pd vref_re $&vref_re t_re $&t_re
quit
.endc
.end
