* M1 post-layout: op on the sch netlist (generated by sim/m1/make_tb.py), tt, 27 C, 1.8 V
.lib /usr/local/share/pdk/sky130A/libs.tech/ngspice/sky130.lib.spice tt
.include /home/user/ttsky26d_analog_ADC/layout/cells/m1_top_ref.spice
.temp 27
.options reltol=1e-5 abstol=1e-12 vntol=1e-7 chgtol=1e-16
xdut vdd 0 bgpd oe rs pad tt_um_chiranjitpatel_sar_adc
CPAD pad 0 5p
RPAD pad pin 500
CDMM pin 0 10p
RDMM pin 0 10meg
* unused pins (other analog pads, VGND-tied outputs): 1 GOhm to ground so they are not floating
VDD vdd 0 1.8
VPD bgpd 0 0
VOE oe 0 0
VRS rs 0 0
VEXT ext 0 1.5
SEXT ext pin rs 0 swx
.model swx sw vt=0.9 vh=0.1 ron=1 roff=1e15
.control
set wr_singlescale
set wr_vecnames
alter VPD dc=0
alter VOE dc=0
alter VRS dc=0
op
echo RES A_internal vbg $&v(xdut.vbg) vbg_f $&v(xdut.vbg_f) vref $&v(xdut.vref) vptat $&v(xdut.vptat) pin $&v(pin) idd $&i(VDD)
alter VPD dc=0
alter VOE dc=1.8
alter VRS dc=0
op
echo RES B_dmm vbg $&v(xdut.vbg) vbg_f $&v(xdut.vbg_f) vref $&v(xdut.vref) vptat $&v(xdut.vptat) pin $&v(pin) idd $&i(VDD)
alter VPD dc=0
alter VOE dc=0
alter VRS dc=1.8
op
echo RES C_extref vbg $&v(xdut.vbg) vbg_f $&v(xdut.vbg_f) vref $&v(xdut.vref) vptat $&v(xdut.vptat) pin $&v(pin) idd $&i(VDD)
alter VPD dc=1.8
alter VOE dc=0
alter VRS dc=0
op
echo RES D_bgpd vbg $&v(xdut.vbg) vbg_f $&v(xdut.vbg_f) vref $&v(xdut.vref) vptat $&v(xdut.vptat) pin $&v(pin) idd $&i(VDD)
quit
.endc
.end
