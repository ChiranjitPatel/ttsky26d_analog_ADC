* M1 post-layout: ac on the rc netlist (generated by sim/m1/make_tb.py), tt, 27 C, 1.8 V
.lib /usr/local/share/pdk/sky130A/libs.tech/ngspice/sky130.lib.spice tt
.include /home/user/ttsky26d_analog_ADC/sim/out/layout/m1_rc/m1_rc.spice
.temp 27
.options reltol=1e-5 abstol=1e-12 vntol=1e-7 chgtol=1e-16
xdut 0 0 0 nc_ua_0_ pad nc_ua_2_ nc_ua_3_ nc_ua_4_ nc_ua_5_ nc_ua_6_ nc_ua_7_ 0 oe 0 bgpd 0 0 0 0 0 0 0 rs 0 0 0 0 nc_uio_oe_0_ nc_uio_oe_1_ nc_uio_oe_2_ nc_uio_oe_3_ nc_uio_oe_4_ nc_uio_oe_5_ nc_uio_oe_6_ nc_uio_oe_7_ nc_uio_out_0_ nc_uio_out_1_ nc_uio_out_2_ nc_uio_out_3_ nc_uio_out_4_ nc_uio_out_5_ nc_uio_out_6_ nc_uio_out_7_ nc_uo_out_0_ nc_uo_out_1_ nc_uo_out_2_ nc_uo_out_3_ nc_uo_out_4_ nc_uo_out_5_ nc_uo_out_6_ nc_uo_out_7_ vdd 0 tt_um_chiranjitpatel_sar_adc
CPAD pad 0 5p
RPAD pad pin 500
CDMM pin 0 10p
RDMM pin 0 10meg
* unused pins (other analog pads, VGND-tied outputs): 1 GOhm to ground so they are not floating
Rnc_ua_0_ nc_ua_0_ 0 1g
Rnc_ua_2_ nc_ua_2_ 0 1g
Rnc_ua_3_ nc_ua_3_ 0 1g
Rnc_ua_4_ nc_ua_4_ 0 1g
Rnc_ua_5_ nc_ua_5_ 0 1g
Rnc_ua_6_ nc_ua_6_ 0 1g
Rnc_ua_7_ nc_ua_7_ 0 1g
Rnc_uio_oe_0_ nc_uio_oe_0_ 0 1g
Rnc_uio_oe_1_ nc_uio_oe_1_ 0 1g
Rnc_uio_oe_2_ nc_uio_oe_2_ 0 1g
Rnc_uio_oe_3_ nc_uio_oe_3_ 0 1g
Rnc_uio_oe_4_ nc_uio_oe_4_ 0 1g
Rnc_uio_oe_5_ nc_uio_oe_5_ 0 1g
Rnc_uio_oe_6_ nc_uio_oe_6_ 0 1g
Rnc_uio_oe_7_ nc_uio_oe_7_ 0 1g
Rnc_uio_out_0_ nc_uio_out_0_ 0 1g
Rnc_uio_out_1_ nc_uio_out_1_ 0 1g
Rnc_uio_out_2_ nc_uio_out_2_ 0 1g
Rnc_uio_out_3_ nc_uio_out_3_ 0 1g
Rnc_uio_out_4_ nc_uio_out_4_ 0 1g
Rnc_uio_out_5_ nc_uio_out_5_ 0 1g
Rnc_uio_out_6_ nc_uio_out_6_ 0 1g
Rnc_uio_out_7_ nc_uio_out_7_ 0 1g
Rnc_uo_out_0_ nc_uo_out_0_ 0 1g
Rnc_uo_out_1_ nc_uo_out_1_ 0 1g
Rnc_uo_out_2_ nc_uo_out_2_ 0 1g
Rnc_uo_out_3_ nc_uo_out_3_ 0 1g
Rnc_uo_out_4_ nc_uo_out_4_ 0 1g
Rnc_uo_out_5_ nc_uo_out_5_ 0 1g
Rnc_uo_out_6_ nc_uo_out_6_ 0 1g
Rnc_uo_out_7_ nc_uo_out_7_ 0 1g
VDD vdd 0 dc 1.8 ac 1
VPD bgpd 0 0
VOE oe 0 0
VRS rs 0 0
.control
set wr_singlescale
set wr_vecnames
ac dec 20 1 1e8
let p_vbg = -db(v(xdut.bandgap_core_0.vbg))
let p_f = -db(v(xdut.vref_filt_0.vbg_f))
let p_ref = -db(v(xdut.vref_sel_0.vref))
wrdata ../out/m1/rc_ac.dat p_vbg p_f p_ref
meas ac pf_dc find p_f at=1
meas ac pf_1m find p_f at=1e6
meas ac pr_dc find p_ref at=1
meas ac pr_1m find p_ref at=1e6
echo RES psrr vbg_f_dc $&pf_dc vbg_f_1m $&pf_1m vref_dc $&pr_dc vref_1m $&pr_1m
quit
.endc
.end
