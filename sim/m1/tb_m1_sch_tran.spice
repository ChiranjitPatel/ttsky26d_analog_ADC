* M1 post-layout: tran on the sch netlist (generated by sim/m1/make_tb.py), tt, 27 C, 1.8 V
.lib /usr/local/share/pdk/sky130A/libs.tech/ngspice/sky130.lib.spice tt
.include /home/user/ttsky26d_analog_ADC/layout/cells/m1_top_ref.spice
.temp 27
.options reltol=1e-4 abstol=1e-12 vntol=1e-6 method=gear
xdut vdd 0 bgpd oe rs pad tt_um_chiranjitpatel_sar_adc
CPAD pad 0 5p
RPAD pad pin 500
CDMM pin 0 10p
RDMM pin 0 10meg
* unused pins (other analog pads, VGND-tied outputs): 1 GOhm to ground so they are not floating
VDD vdd 0 dc 0 pulse(0 1.8 0 1u 1u 1 2)
VOE oe 0 dc 0 pulse(0 1.8 150u 10n 10n 1 2)
VPD bgpd 0 dc 0 pulse(0 1.8 250u 10n 10n 50u 1)
VRS rs 0 0
.control
set wr_singlescale
set wr_vecnames
save v(xdut.vbg) v(xdut.vbg_f) v(xdut.vref) v(xdut.vptat) v(pin) i(VDD)
tran 50n 450u uic
wrdata ../out/m1/sch_tran.dat v(xdut.vbg) v(xdut.vbg_f) v(xdut.vref) v(xdut.vptat) v(pin)
meas tran vref_end find v(xdut.vref) at=149u
meas tran t_up when v(xdut.vref)=0.99*vref_end rise=1
meas tran pin_end find v(pin) at=249u
meas tran vref_pd find v(xdut.vref) at=299u
meas tran idd_pd find i(VDD) at=299u
meas tran vref_re find v(xdut.vref) at=449u
meas tran t_re when v(xdut.vref)=0.99*vref_re rise=last
echo RES tran vref_end $&vref_end t_up $&t_up pin_end $&pin_end vref_pd $&vref_pd idd_pd $&idd_pd vref_re $&vref_re t_re $&t_re
quit
.endc
.end
