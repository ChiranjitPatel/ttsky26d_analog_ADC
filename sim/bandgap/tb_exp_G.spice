* bandgap_core Monte Carlo (Phase 2): mismatch only (tt_mm), 27 C, VDPWR 1.8 V.
* Run with: ../../tools/run_corners.py tb_bandgap_mc.spice --mc 100 --mc-corner tt_mm
* Each seed: VBG, the OTA input difference vb - va (offset seen by the loop) and VBG at -40/125 C.
.lib /usr/local/share/pdk/sky130A/libs.tech/ngspice/sky130.lib.spice tt
.include ../out/netlist/bias_gen.spice
.include ../out/netlist/exp_G.spice
.temp 27
.options method=gear
.nodeset v(vgp)=0.75 v(vbg)=1.2

VDD  vdd  0 1.8
VPD  pd   0 0
xb   vdd  0 pd nbias pbias bias_gen
xbg  vdd  0 pbias pd vbg vgp bandgap_core

.control
op
let dv_in = v(xbg.vb) - v(xbg.va)
print v(vbg) dv_in
dc temp -40 125 165
let vbgm40 = v(vbg)[0]
let vbg125 = v(vbg)[1]
print vbgm40 vbg125
quit
.endc
.end
