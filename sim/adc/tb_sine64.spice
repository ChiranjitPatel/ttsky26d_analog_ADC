* I2 — adc_core with ideal VREF: 64 conversions (generated by make_tb.py)
.lib /usr/local/share/pdk/sky130A/libs.tech/ngspice/sky130.lib.spice tt
.include /usr/local/share/pdk/sky130A/libs.ref/sky130_fd_sc_hd/spice/sky130_fd_sc_hd.spice
.include ../out/netlist/bias_gen.spice
.include ../out/netlist/sar_logic.spice
.include ../out/netlist/adc_core.spice
.temp 27
.options reltol=1e-5 abstol=1e-12 vntol=1e-7 chgtol=1e-16
VDD vdd 0 1.8
VPD pd 0 0
xb vdd 0 pd nbias pbias bias_gen
VREF vref 0 1.215
VCLK clk 0 pulse(0 1.8 0.5u 0.5n 0.5n 0.5u 1u)
VRST rst_n 0 pwl(0 0 1.5u 0 1.501u 1.8)
VST start 0 1.8
VMODE mode 0 0
VZ z 0 0
VIN vsrc 0 pwl(1.5e-06 0.6075 1.1499e-05 0.6075 1.15e-05 0.975448105 2.1499e-05 0.975448105 2.15e-05 1.17635546 3.1499e-05 1.17635546 3.15e-05 1.11901433 4.1499e-05 1.11901433 4.15e-05 0.829456391 5.1499e-05 0.829456391 5.15e-05 0.439134887 6.1499e-05 0.439134887 6.15e-05 0.125247625 7.1499e-05 0.125247625 7.15e-05 0.0302928585 8.1499e-05 0.0302928585 8.15e-05 0.197378067 9.1499e-05 0.197378067 9.15e-05 0.550650059 0.000101499 0.550650059 0.0001015 0.929730735 0.000111499 0.929730735 0.0001115 1.16252539 0.000121499 1.16252539 0.0001215 1.14335013 0.000131499 1.14335013 0.0001315 0.880910107 0.000141499 0.880910107 0.0001415 0.494347613 0.000151499 0.494347613 0.0001515 0.159153937 0.000161499 0.159153937 0.0001615 0.0275 0.000171499 0.0275 0.0001715 0.159153937 0.000181499 0.159153937 0.0001815 0.494347613 0.000191499 0.494347613 0.0001915 0.880910107 0.000201499 0.880910107 0.0002015 1.14335013 0.000211499 1.14335013 0.0002115 1.16252539 0.000221499 1.16252539 0.0002215 0.929730735 0.000231499 0.929730735 0.0002315 0.550650059 0.000241499 0.550650059 0.0002415 0.197378067 0.000251499 0.197378067 0.0002515 0.0302928585 0.000261499 0.0302928585 0.0002615 0.125247625 0.000271499 0.125247625 0.0002715 0.439134887 0.000281499 0.439134887 0.0002815 0.829456391 0.000291499 0.829456391 0.0002915 1.11901433 0.000301499 1.11901433 0.0003015 1.17635546 0.000311499 1.17635546 0.0003115 0.975448105 0.000321499 0.975448105 0.0003215 0.6075 0.000331499 0.6075 0.0003315 0.239551895 0.000341499 0.239551895 0.0003415 0.0386445374 0.000351499 0.0386445374 0.0003515 0.0959856667 0.000361499 0.0959856667 0.0003615 0.385543609 0.000371499 0.385543609 0.0003715 0.775865113 0.000381499 0.775865113 0.0003815 1.08975238 0.000391499 1.08975238 0.0003915 1.18470714 0.000401499 1.18470714 0.0004015 1.01762193 0.000411499 1.01762193 0.0004115 0.664349941 0.000421499 0.664349941 0.0004215 0.285269265 0.000431499 0.285269265 0.0004315 0.0524746053 0.000441499 0.0524746053 0.0004415 0.0716498711 0.000451499 0.0716498711 0.0004515 0.334089893 0.000461499 0.334089893 0.0004615 0.720652387 0.000471499 0.720652387 0.0004715 1.05584606 0.000481499 1.05584606 0.0004815 1.1875 0.000491499 1.1875 0.0004915 1.05584606 0.000501499 1.05584606 0.0005015 0.720652387 0.000511499 0.720652387 0.0005115 0.334089893 0.000521499 0.334089893 0.0005215 0.0716498711 0.000531499 0.0716498711 0.0005315 0.0524746053 0.000541499 0.0524746053 0.0005415 0.285269265 0.000551499 0.285269265 0.0005515 0.664349941 0.000561499 0.664349941 0.0005615 1.01762193 0.000571499 1.01762193 0.0005715 1.18470714 0.000581499 1.18470714 0.0005815 1.08975238 0.000591499 1.08975238 0.0005915 0.775865113 0.000601499 0.775865113 0.0006015 0.385543609 0.000611499 0.385543609 0.0006115 0.0959856667 0.000621499 0.0959856667 0.0006215 0.0386445374 0.000631499 0.0386445374 0.0006315 0.239551895 0.000641499 0.239551895)
RPAD vsrc vadc_pad 500
CPAD vadc_pad 0 5p
x1 vdd 0 pbias vref vadc_pad clk rst_n start mode z z z z z z z z z z d0 d1 d2 d3 d4 d5 d6 d7 eoc cmp adc_core
.control
set wr_singlescale
set wr_vecnames
save v(clk) v(eoc) v(vsrc) v(x1.vtop) v(x1.vcm) v(x1.smpt) v(vref) v(d0) v(d1) v(d2) v(d3) v(d4) v(d5) v(d6) v(d7)
tran 2n 0.000645
wrdata ../out/adc/sine64.dat v(clk) v(eoc) v(vsrc) v(x1.vtop) v(x1.vcm) v(x1.smpt) v(d0) v(d1) v(d2) v(d3) v(d4) v(d5) v(d6) v(d7) v(vref)
quit
.endc
.end
