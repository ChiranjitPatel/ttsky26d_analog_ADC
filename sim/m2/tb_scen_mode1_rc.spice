* I4 scenario 'mode1' on the rc netlist (generated by sim/m2/scenarios.py), tt, 27 C, 1.8 V
.lib /usr/local/share/pdk/sky130A/libs.tech/ngspice/sky130.lib.spice tt
.include /usr/local/share/pdk/sky130A/libs.ref/sky130_fd_sc_hd/spice/sky130_fd_sc_hd.spice
.include /home/user/ttsky26d_analog_ADC/sim/out/layout/m2_rc/m2_rc.spice
.temp 27
.options reltol=1e-5 abstol=1e-12 vntol=1e-6 method=gear rshunt=1e12
xdut clk 0 rst_n pad0 pad1 nc_ua_2_ nc_ua_3_ nc_ua_4_ nc_ua_5_ nc_ua_6_ nc_ua_7_ ext_d0 ext_d1 ext_d2 ext_d3 ext_d4 ext_d5 ext_d6 ext_d7 vdd ext_sample ext_cmp_clk 0 0 0 0 0 nc_uio_oe_0_ nc_uio_oe_1_ nc_uio_oe_2_ nc_uio_oe_3_ nc_uio_oe_4_ nc_uio_oe_5_ nc_uio_oe_6_ nc_uio_oe_7_ nc_uio_out_0_ nc_uio_out_1_ nc_uio_out_2_ nc_uio_out_3_ cmp eoc nc_uio_out_6_ nc_uio_out_7_ d0 d1 d2 d3 d4 d5 d6 d7 vdd 0 tt_um_chiranjitpatel_sar_adc
VDD vdd 0 1.8
VCLK clk 0 pulse(0 1.8 5e-07 0.5n 0.5n 5e-07 1e-06)
VRST rst_n 0 pwl(0 0 1.5u 0 1.501u 1.8)
VST start 0 pwl(0 0 1.4e-06 0 1.401e-06 1.8)
VIN vsrc 0 pwl(1.5e-06 0.6 1.1499e-05 0.6)
RPAD0 vsrc pad0 500
CPAD0 pad0 0 5p
CPAD1 pad1 0 5p
RPAD1 pad1 pin1 500
CDMM pin1 0 10p
RDMM pin1 0 10meg
VEXS ext_sample 0 pwl(0 1.8 3e-06 1.8 3.001e-06 0)
VEXC ext_cmp_clk 0 pwl(0 0 3.6e-06 0 3.601e-06 1.8 3.8e-06 1.8 3.801e-06 0 4.6e-06 0 4.601e-06 1.8 4.8e-06 1.8 4.801e-06 0 5.6e-06 0 5.601e-06 1.8 5.8e-06 1.8 5.801e-06 0 6.6e-06 0 6.601e-06 1.8 6.8e-06 1.8 6.801e-06 0)
VEXD0 ext_d0 0 pwl(0 0 3.199e-06 0 3.2e-06 0 4.199e-06 0 4.2e-06 0 5.199e-06 0 5.2e-06 1.8 6.199e-06 1.8 6.2e-06 1.8)
VEXD1 ext_d1 0 pwl(0 0 3.199e-06 0 3.2e-06 0 4.199e-06 0 4.2e-06 1.8 5.199e-06 1.8 5.2e-06 1.8 6.199e-06 1.8 6.2e-06 0)
VEXD2 ext_d2 0 pwl(0 0 3.199e-06 0 3.2e-06 0 4.199e-06 0 4.2e-06 1.8 5.199e-06 1.8 5.2e-06 1.8 6.199e-06 1.8 6.2e-06 1.8)
VEXD3 ext_d3 0 pwl(0 0 3.199e-06 0 3.2e-06 1.8 4.199e-06 1.8 4.2e-06 1.8 5.199e-06 1.8 5.2e-06 1.8 6.199e-06 1.8 6.2e-06 0)
VEXD4 ext_d4 0 pwl(0 0 3.199e-06 0 3.2e-06 1.8 4.199e-06 1.8 4.2e-06 1.8 5.199e-06 1.8 5.2e-06 1.8 6.199e-06 1.8 6.2e-06 0)
VEXD5 ext_d5 0 pwl(0 0 3.199e-06 0 3.2e-06 1.8 4.199e-06 1.8 4.2e-06 1.8 5.199e-06 1.8 5.2e-06 1.8 6.199e-06 1.8 6.2e-06 0)
VEXD6 ext_d6 0 pwl(0 0 3.199e-06 0 3.2e-06 1.8 4.199e-06 1.8 4.2e-06 1.8 5.199e-06 1.8 5.2e-06 1.8 6.199e-06 1.8 6.2e-06 0)
VEXD7 ext_d7 0 pwl(0 0 3.199e-06 0 3.2e-06 0 4.199e-06 0 4.2e-06 0 5.199e-06 0 5.2e-06 0 6.199e-06 0 6.2e-06 1.8)
.nodeset v(xdut.inmux_0.vbg)=1.21 v(xdut.vref_buf_0.in)=1.21 v(xdut.vref_filt_0.RF.R1_1.n0)=1.21 v(xdut.vref_filt_0.RF.R1_1.n1)=1.21 v(xdut.vref_filt_0.RF.R1_1.n10)=1.21 v(xdut.vref_filt_0.RF.R1_1.n11)=1.21 v(xdut.vref_filt_0.RF.R1_1.n12)=1.21 v(xdut.vref_filt_0.RF.R1_1.n13)=1.21 v(xdut.vref_filt_0.RF.R1_1.n14)=1.21 v(xdut.vref_filt_0.RF.R1_1.n15)=1.21 v(xdut.vref_filt_0.RF.R1_1.n16)=1.21 v(xdut.vref_filt_0.RF.R1_1.n17)=1.21 v(xdut.vref_filt_0.RF.R1_1.n18)=1.21 v(xdut.vref_filt_0.RF.R1_1.n19)=1.21 v(xdut.vref_filt_0.RF.R1_1.n2)=1.21 v(xdut.vref_filt_0.RF.R1_1.n20)=1.21 v(xdut.vref_filt_0.RF.R1_1.n21)=1.21 v(xdut.vref_filt_0.RF.R1_1.n22)=1.21 v(xdut.vref_filt_0.RF.R1_1.n23)=1.21 v(xdut.vref_filt_0.RF.R1_1.n24)=1.21 v(xdut.vref_filt_0.RF.R1_1.n25)=1.21 v(xdut.vref_filt_0.RF.R1_1.n3)=1.21 v(xdut.vref_filt_0.RF.R1_1.n4)=1.21 v(xdut.vref_filt_0.RF.R1_1.n5)=1.21 v(xdut.vref_filt_0.RF.R1_1.n6)=1.21 v(xdut.vref_filt_0.RF.R1_1.n7)=1.21 v(xdut.vref_filt_0.RF.R1_1.n8)=1.21 v(xdut.vref_filt_0.RF.R1_1.n9)=1.21 v(xdut.vref_filt_0.RF.R1_1.t0)=1.21 v(xdut.vref_filt_0.RF.R1_1.t1)=1.21 v(xdut.vref_filt_0.RF.R1_11.n0)=1.21 v(xdut.vref_filt_0.RF.R1_11.n1)=1.21 v(xdut.vref_filt_0.RF.R1_11.n10)=1.21 v(xdut.vref_filt_0.RF.R1_11.n11)=1.21 v(xdut.vref_filt_0.RF.R1_11.n12)=1.21 v(xdut.vref_filt_0.RF.R1_11.n13)=1.21 v(xdut.vref_filt_0.RF.R1_11.n14)=1.21 v(xdut.vref_filt_0.RF.R1_11.n15)=1.21 v(xdut.vref_filt_0.RF.R1_11.n16)=1.21 v(xdut.vref_filt_0.RF.R1_11.n17)=1.21 v(xdut.vref_filt_0.RF.R1_11.n18)=1.21 v(xdut.vref_filt_0.RF.R1_11.n19)=1.21 v(xdut.vref_filt_0.RF.R1_11.n2)=1.21 v(xdut.vref_filt_0.RF.R1_11.n20)=1.21 v(xdut.vref_filt_0.RF.R1_11.n21)=1.21 v(xdut.vref_filt_0.RF.R1_11.n22)=1.21 v(xdut.vref_filt_0.RF.R1_11.n23)=1.21 v(xdut.vref_filt_0.RF.R1_11.n24)=1.21 v(xdut.vref_filt_0.RF.R1_11.n25)=1.21 v(xdut.vref_filt_0.RF.R1_11.n3)=1.21 v(xdut.vref_filt_0.RF.R1_11.n4)=1.21 v(xdut.vref_filt_0.RF.R1_11.n5)=1.21 v(xdut.vref_filt_0.RF.R1_11.n6)=1.21 v(xdut.vref_filt_0.RF.R1_11.n7)=1.21 v(xdut.vref_filt_0.RF.R1_11.n8)=1.21 v(xdut.vref_filt_0.RF.R1_11.n9)=1.21 v(xdut.vref_filt_0.RF.R1_11.t0)=1.21 v(xdut.vref_filt_0.RF.R1_11.t1)=1.21 v(xdut.vref_filt_0.RF.R1_13.n0)=1.21 v(xdut.vref_filt_0.RF.R1_13.n1)=1.21 v(xdut.vref_filt_0.RF.R1_13.n10)=1.21 v(xdut.vref_filt_0.RF.R1_13.n11)=1.21 v(xdut.vref_filt_0.RF.R1_13.n12)=1.21 v(xdut.vref_filt_0.RF.R1_13.n13)=1.21 v(xdut.vref_filt_0.RF.R1_13.n14)=1.21 v(xdut.vref_filt_0.RF.R1_13.n15)=1.21 v(xdut.vref_filt_0.RF.R1_13.n16)=1.21 v(xdut.vref_filt_0.RF.R1_13.n17)=1.21 v(xdut.vref_filt_0.RF.R1_13.n18)=1.21 v(xdut.vref_filt_0.RF.R1_13.n19)=1.21 v(xdut.vref_filt_0.RF.R1_13.n2)=1.21 v(xdut.vref_filt_0.RF.R1_13.n20)=1.21 v(xdut.vref_filt_0.RF.R1_13.n21)=1.21 v(xdut.vref_filt_0.RF.R1_13.n22)=1.21 v(xdut.vref_filt_0.RF.R1_13.n23)=1.21 v(xdut.vref_filt_0.RF.R1_13.n24)=1.21 v(xdut.vref_filt_0.RF.R1_13.n25)=1.21 v(xdut.vref_filt_0.RF.R1_13.n3)=1.21 v(xdut.vref_filt_0.RF.R1_13.n4)=1.21 v(xdut.vref_filt_0.RF.R1_13.n5)=1.21 v(xdut.vref_filt_0.RF.R1_13.n6)=1.21 v(xdut.vref_filt_0.RF.R1_13.n7)=1.21 v(xdut.vref_filt_0.RF.R1_13.n8)=1.21 v(xdut.vref_filt_0.RF.R1_13.n9)=1.21 v(xdut.vref_filt_0.RF.R1_13.t0)=1.21 v(xdut.vref_filt_0.RF.R1_13.t1)=1.21 v(xdut.vref_filt_0.RF.R1_3.n0)=1.21 v(xdut.vref_filt_0.RF.R1_3.n1)=1.21 v(xdut.vref_filt_0.RF.R1_3.n10)=1.21 v(xdut.vref_filt_0.RF.R1_3.n11)=1.21 v(xdut.vref_filt_0.RF.R1_3.n12)=1.21 v(xdut.vref_filt_0.RF.R1_3.n13)=1.21 v(xdut.vref_filt_0.RF.R1_3.n14)=1.21 v(xdut.vref_filt_0.RF.R1_3.n15)=1.21 v(xdut.vref_filt_0.RF.R1_3.n16)=1.21 v(xdut.vref_filt_0.RF.R1_3.n17)=1.21 v(xdut.vref_filt_0.RF.R1_3.n18)=1.21 v(xdut.vref_filt_0.RF.R1_3.n19)=1.21 v(xdut.vref_filt_0.RF.R1_3.n2)=1.21 v(xdut.vref_filt_0.RF.R1_3.n20)=1.21 v(xdut.vref_filt_0.RF.R1_3.n21)=1.21 v(xdut.vref_filt_0.RF.R1_3.n22)=1.21 v(xdut.vref_filt_0.RF.R1_3.n23)=1.21 v(xdut.vref_filt_0.RF.R1_3.n24)=1.21 v(xdut.vref_filt_0.RF.R1_3.n25)=1.21 v(xdut.vref_filt_0.RF.R1_3.n3)=1.21 v(xdut.vref_filt_0.RF.R1_3.n4)=1.21 v(xdut.vref_filt_0.RF.R1_3.n5)=1.21 v(xdut.vref_filt_0.RF.R1_3.n6)=1.21 v(xdut.vref_filt_0.RF.R1_3.n7)=1.21 v(xdut.vref_filt_0.RF.R1_3.n8)=1.21 v(xdut.vref_filt_0.RF.R1_3.n9)=1.21 v(xdut.vref_filt_0.RF.R1_3.t0)=1.21 v(xdut.vref_filt_0.RF.R1_3.t1)=1.21 v(xdut.vref_filt_0.RF.R1_5.n0)=1.21 v(xdut.vref_filt_0.RF.R1_5.n1)=1.21 v(xdut.vref_filt_0.RF.R1_5.n10)=1.21 v(xdut.vref_filt_0.RF.R1_5.n11)=1.21 v(xdut.vref_filt_0.RF.R1_5.n12)=1.21 v(xdut.vref_filt_0.RF.R1_5.n13)=1.21 v(xdut.vref_filt_0.RF.R1_5.n14)=1.21 v(xdut.vref_filt_0.RF.R1_5.n15)=1.21 v(xdut.vref_filt_0.RF.R1_5.n16)=1.21 v(xdut.vref_filt_0.RF.R1_5.n17)=1.21 v(xdut.vref_filt_0.RF.R1_5.n18)=1.21 v(xdut.vref_filt_0.RF.R1_5.n19)=1.21 v(xdut.vref_filt_0.RF.R1_5.n2)=1.21 v(xdut.vref_filt_0.RF.R1_5.n20)=1.21 v(xdut.vref_filt_0.RF.R1_5.n21)=1.21 v(xdut.vref_filt_0.RF.R1_5.n22)=1.21 v(xdut.vref_filt_0.RF.R1_5.n23)=1.21 v(xdut.vref_filt_0.RF.R1_5.n24)=1.21 v(xdut.vref_filt_0.RF.R1_5.n25)=1.21 v(xdut.vref_filt_0.RF.R1_5.n3)=1.21 v(xdut.vref_filt_0.RF.R1_5.n4)=1.21 v(xdut.vref_filt_0.RF.R1_5.n5)=1.21 v(xdut.vref_filt_0.RF.R1_5.n6)=1.21 v(xdut.vref_filt_0.RF.R1_5.n7)=1.21 v(xdut.vref_filt_0.RF.R1_5.n8)=1.21 v(xdut.vref_filt_0.RF.R1_5.n9)=1.21 v(xdut.vref_filt_0.RF.R1_5.t0)=1.21 v(xdut.vref_filt_0.RF.R1_5.t1)=1.21 v(xdut.vref_filt_0.RF.R1_7.n0)=1.21 v(xdut.vref_filt_0.RF.R1_7.n1)=1.21 v(xdut.vref_filt_0.RF.R1_7.n10)=1.21 v(xdut.vref_filt_0.RF.R1_7.n11)=1.21 v(xdut.vref_filt_0.RF.R1_7.n12)=1.21 v(xdut.vref_filt_0.RF.R1_7.n13)=1.21 v(xdut.vref_filt_0.RF.R1_7.n14)=1.21 v(xdut.vref_filt_0.RF.R1_7.n15)=1.21 v(xdut.vref_filt_0.RF.R1_7.n16)=1.21 v(xdut.vref_filt_0.RF.R1_7.n17)=1.21 v(xdut.vref_filt_0.RF.R1_7.n18)=1.21 v(xdut.vref_filt_0.RF.R1_7.n19)=1.21 v(xdut.vref_filt_0.RF.R1_7.n2)=1.21 v(xdut.vref_filt_0.RF.R1_7.n20)=1.21 v(xdut.vref_filt_0.RF.R1_7.n21)=1.21 v(xdut.vref_filt_0.RF.R1_7.n22)=1.21 v(xdut.vref_filt_0.RF.R1_7.n23)=1.21 v(xdut.vref_filt_0.RF.R1_7.n24)=1.21 v(xdut.vref_filt_0.RF.R1_7.n25)=1.21 v(xdut.vref_filt_0.RF.R1_7.n3)=1.21 v(xdut.vref_filt_0.RF.R1_7.n4)=1.21 v(xdut.vref_filt_0.RF.R1_7.n5)=1.21 v(xdut.vref_filt_0.RF.R1_7.n6)=1.21 v(xdut.vref_filt_0.RF.R1_7.n7)=1.21 v(xdut.vref_filt_0.RF.R1_7.n8)=1.21 v(xdut.vref_filt_0.RF.R1_7.n9)=1.21 v(xdut.vref_filt_0.RF.R1_7.t0)=1.21 v(xdut.vref_filt_0.RF.R1_7.t1)=1.21 v(xdut.vref_filt_0.RF.R1_9.n0)=1.21 v(xdut.vref_filt_0.RF.R1_9.n1)=1.21 v(xdut.vref_filt_0.RF.R1_9.n10)=1.21 v(xdut.vref_filt_0.RF.R1_9.n11)=1.21 v(xdut.vref_filt_0.RF.R1_9.n12)=1.21 v(xdut.vref_filt_0.RF.R1_9.n13)=1.21 v(xdut.vref_filt_0.RF.R1_9.n14)=1.21 v(xdut.vref_filt_0.RF.R1_9.n15)=1.21 v(xdut.vref_filt_0.RF.R1_9.n16)=1.21 v(xdut.vref_filt_0.RF.R1_9.n17)=1.21 v(xdut.vref_filt_0.RF.R1_9.n18)=1.21 v(xdut.vref_filt_0.RF.R1_9.n19)=1.21 v(xdut.vref_filt_0.RF.R1_9.n2)=1.21 v(xdut.vref_filt_0.RF.R1_9.n20)=1.21 v(xdut.vref_filt_0.RF.R1_9.n21)=1.21 v(xdut.vref_filt_0.RF.R1_9.n22)=1.21 v(xdut.vref_filt_0.RF.R1_9.n23)=1.21 v(xdut.vref_filt_0.RF.R1_9.n24)=1.21 v(xdut.vref_filt_0.RF.R1_9.n25)=1.21 v(xdut.vref_filt_0.RF.R1_9.n3)=1.21 v(xdut.vref_filt_0.RF.R1_9.n4)=1.21 v(xdut.vref_filt_0.RF.R1_9.n5)=1.21 v(xdut.vref_filt_0.RF.R1_9.n6)=1.21 v(xdut.vref_filt_0.RF.R1_9.n7)=1.21 v(xdut.vref_filt_0.RF.R1_9.n8)=1.21 v(xdut.vref_filt_0.RF.R1_9.n9)=1.21 v(xdut.vref_filt_0.RF.R1_9.t0)=1.21 v(xdut.vref_filt_0.RF.R1_9.t1)=1.21 v(xdut.vref_filt_0.RF.R2_10.n0)=1.21 v(xdut.vref_filt_0.RF.R2_10.n1)=1.21 v(xdut.vref_filt_0.RF.R2_10.n10)=1.21 v(xdut.vref_filt_0.RF.R2_10.n11)=1.21 v(xdut.vref_filt_0.RF.R2_10.n12)=1.21 v(xdut.vref_filt_0.RF.R2_10.n13)=1.21 v(xdut.vref_filt_0.RF.R2_10.n14)=1.21 v(xdut.vref_filt_0.RF.R2_10.n15)=1.21 v(xdut.vref_filt_0.RF.R2_10.n16)=1.21 v(xdut.vref_filt_0.RF.R2_10.n17)=1.21 v(xdut.vref_filt_0.RF.R2_10.n18)=1.21 v(xdut.vref_filt_0.RF.R2_10.n19)=1.21 v(xdut.vref_filt_0.RF.R2_10.n2)=1.21 v(xdut.vref_filt_0.RF.R2_10.n20)=1.21 v(xdut.vref_filt_0.RF.R2_10.n21)=1.21 v(xdut.vref_filt_0.RF.R2_10.n22)=1.21 v(xdut.vref_filt_0.RF.R2_10.n23)=1.21 v(xdut.vref_filt_0.RF.R2_10.n24)=1.21 v(xdut.vref_filt_0.RF.R2_10.n25)=1.21 v(xdut.vref_filt_0.RF.R2_10.n3)=1.21 v(xdut.vref_filt_0.RF.R2_10.n4)=1.21 v(xdut.vref_filt_0.RF.R2_10.n5)=1.21 v(xdut.vref_filt_0.RF.R2_10.n6)=1.21 v(xdut.vref_filt_0.RF.R2_10.n7)=1.21 v(xdut.vref_filt_0.RF.R2_10.n8)=1.21 v(xdut.vref_filt_0.RF.R2_10.n9)=1.21 v(xdut.vref_filt_0.RF.R2_10.t0)=1.21 v(xdut.vref_filt_0.RF.R2_10.t1)=1.21 v(xdut.vref_filt_0.RF.R2_12.n0)=1.21 v(xdut.vref_filt_0.RF.R2_12.n1)=1.21 v(xdut.vref_filt_0.RF.R2_12.n10)=1.21 v(xdut.vref_filt_0.RF.R2_12.n11)=1.21 v(xdut.vref_filt_0.RF.R2_12.n12)=1.21 v(xdut.vref_filt_0.RF.R2_12.n13)=1.21 v(xdut.vref_filt_0.RF.R2_12.n14)=1.21 v(xdut.vref_filt_0.RF.R2_12.n15)=1.21 v(xdut.vref_filt_0.RF.R2_12.n16)=1.21 v(xdut.vref_filt_0.RF.R2_12.n17)=1.21 v(xdut.vref_filt_0.RF.R2_12.n18)=1.21 v(xdut.vref_filt_0.RF.R2_12.n19)=1.21 v(xdut.vref_filt_0.RF.R2_12.n2)=1.21 v(xdut.vref_filt_0.RF.R2_12.n20)=1.21 v(xdut.vref_filt_0.RF.R2_12.n21)=1.21 v(xdut.vref_filt_0.RF.R2_12.n22)=1.21 v(xdut.vref_filt_0.RF.R2_12.n23)=1.21 v(xdut.vref_filt_0.RF.R2_12.n24)=1.21 v(xdut.vref_filt_0.RF.R2_12.n25)=1.21 v(xdut.vref_filt_0.RF.R2_12.n3)=1.21 v(xdut.vref_filt_0.RF.R2_12.n4)=1.21 v(xdut.vref_filt_0.RF.R2_12.n5)=1.21 v(xdut.vref_filt_0.RF.R2_12.n6)=1.21 v(xdut.vref_filt_0.RF.R2_12.n7)=1.21 v(xdut.vref_filt_0.RF.R2_12.n8)=1.21 v(xdut.vref_filt_0.RF.R2_12.n9)=1.21 v(xdut.vref_filt_0.RF.R2_12.t0)=1.21 v(xdut.vref_filt_0.RF.R2_12.t1)=1.21 v(xdut.vref_filt_0.RF.R2_2.n0)=1.21 v(xdut.vref_filt_0.RF.R2_2.n1)=1.21 v(xdut.vref_filt_0.RF.R2_2.n10)=1.21 v(xdut.vref_filt_0.RF.R2_2.n11)=1.21 v(xdut.vref_filt_0.RF.R2_2.n12)=1.21 v(xdut.vref_filt_0.RF.R2_2.n13)=1.21 v(xdut.vref_filt_0.RF.R2_2.n14)=1.21 v(xdut.vref_filt_0.RF.R2_2.n15)=1.21 v(xdut.vref_filt_0.RF.R2_2.n16)=1.21 v(xdut.vref_filt_0.RF.R2_2.n17)=1.21 v(xdut.vref_filt_0.RF.R2_2.n18)=1.21 v(xdut.vref_filt_0.RF.R2_2.n19)=1.21 v(xdut.vref_filt_0.RF.R2_2.n2)=1.21 v(xdut.vref_filt_0.RF.R2_2.n20)=1.21 v(xdut.vref_filt_0.RF.R2_2.n21)=1.21 v(xdut.vref_filt_0.RF.R2_2.n22)=1.21 v(xdut.vref_filt_0.RF.R2_2.n23)=1.21 v(xdut.vref_filt_0.RF.R2_2.n24)=1.21 v(xdut.vref_filt_0.RF.R2_2.n25)=1.21 v(xdut.vref_filt_0.RF.R2_2.n3)=1.21 v(xdut.vref_filt_0.RF.R2_2.n4)=1.21 v(xdut.vref_filt_0.RF.R2_2.n5)=1.21 v(xdut.vref_filt_0.RF.R2_2.n6)=1.21 v(xdut.vref_filt_0.RF.R2_2.n7)=1.21 v(xdut.vref_filt_0.RF.R2_2.n8)=1.21 v(xdut.vref_filt_0.RF.R2_2.n9)=1.21 v(xdut.vref_filt_0.RF.R2_2.t0)=1.21 v(xdut.vref_filt_0.RF.R2_2.t1)=1.21 v(xdut.vref_filt_0.RF.R2_4.n0)=1.21 v(xdut.vref_filt_0.RF.R2_4.n1)=1.21 v(xdut.vref_filt_0.RF.R2_4.n10)=1.21 v(xdut.vref_filt_0.RF.R2_4.n11)=1.21 v(xdut.vref_filt_0.RF.R2_4.n12)=1.21 v(xdut.vref_filt_0.RF.R2_4.n13)=1.21 v(xdut.vref_filt_0.RF.R2_4.n14)=1.21 v(xdut.vref_filt_0.RF.R2_4.n15)=1.21 v(xdut.vref_filt_0.RF.R2_4.n16)=1.21 v(xdut.vref_filt_0.RF.R2_4.n17)=1.21 v(xdut.vref_filt_0.RF.R2_4.n18)=1.21 v(xdut.vref_filt_0.RF.R2_4.n19)=1.21 v(xdut.vref_filt_0.RF.R2_4.n2)=1.21 v(xdut.vref_filt_0.RF.R2_4.n20)=1.21 v(xdut.vref_filt_0.RF.R2_4.n21)=1.21 v(xdut.vref_filt_0.RF.R2_4.n22)=1.21 v(xdut.vref_filt_0.RF.R2_4.n23)=1.21 v(xdut.vref_filt_0.RF.R2_4.n24)=1.21 v(xdut.vref_filt_0.RF.R2_4.n25)=1.21 v(xdut.vref_filt_0.RF.R2_4.n3)=1.21 v(xdut.vref_filt_0.RF.R2_4.n4)=1.21 v(xdut.vref_filt_0.RF.R2_4.n5)=1.21 v(xdut.vref_filt_0.RF.R2_4.n6)=1.21 v(xdut.vref_filt_0.RF.R2_4.n7)=1.21 v(xdut.vref_filt_0.RF.R2_4.n8)=1.21 v(xdut.vref_filt_0.RF.R2_4.n9)=1.21 v(xdut.vref_filt_0.RF.R2_4.t0)=1.21 v(xdut.vref_filt_0.RF.R2_4.t1)=1.21 v(xdut.vref_filt_0.RF.R2_6.n0)=1.21 v(xdut.vref_filt_0.RF.R2_6.n1)=1.21 v(xdut.vref_filt_0.RF.R2_6.n10)=1.21 v(xdut.vref_filt_0.RF.R2_6.n11)=1.21 v(xdut.vref_filt_0.RF.R2_6.n12)=1.21 v(xdut.vref_filt_0.RF.R2_6.n13)=1.21 v(xdut.vref_filt_0.RF.R2_6.n14)=1.21 v(xdut.vref_filt_0.RF.R2_6.n15)=1.21 v(xdut.vref_filt_0.RF.R2_6.n16)=1.21 v(xdut.vref_filt_0.RF.R2_6.n17)=1.21 v(xdut.vref_filt_0.RF.R2_6.n18)=1.21 v(xdut.vref_filt_0.RF.R2_6.n19)=1.21 v(xdut.vref_filt_0.RF.R2_6.n2)=1.21 v(xdut.vref_filt_0.RF.R2_6.n20)=1.21 v(xdut.vref_filt_0.RF.R2_6.n21)=1.21 v(xdut.vref_filt_0.RF.R2_6.n22)=1.21 v(xdut.vref_filt_0.RF.R2_6.n23)=1.21 v(xdut.vref_filt_0.RF.R2_6.n24)=1.21 v(xdut.vref_filt_0.RF.R2_6.n25)=1.21 v(xdut.vref_filt_0.RF.R2_6.n3)=1.21 v(xdut.vref_filt_0.RF.R2_6.n4)=1.21 v(xdut.vref_filt_0.RF.R2_6.n5)=1.21 v(xdut.vref_filt_0.RF.R2_6.n6)=1.21 v(xdut.vref_filt_0.RF.R2_6.n7)=1.21 v(xdut.vref_filt_0.RF.R2_6.n8)=1.21 v(xdut.vref_filt_0.RF.R2_6.n9)=1.21 v(xdut.vref_filt_0.RF.R2_6.t0)=1.21 v(xdut.vref_filt_0.RF.R2_6.t1)=1.21 v(xdut.vref_filt_0.RF.R2_8.n0)=1.21 v(xdut.vref_filt_0.RF.R2_8.n1)=1.21 v(xdut.vref_filt_0.RF.R2_8.n10)=1.21 v(xdut.vref_filt_0.RF.R2_8.n11)=1.21 v(xdut.vref_filt_0.RF.R2_8.n12)=1.21 v(xdut.vref_filt_0.RF.R2_8.n13)=1.21 v(xdut.vref_filt_0.RF.R2_8.n14)=1.21 v(xdut.vref_filt_0.RF.R2_8.n15)=1.21 v(xdut.vref_filt_0.RF.R2_8.n16)=1.21 v(xdut.vref_filt_0.RF.R2_8.n17)=1.21 v(xdut.vref_filt_0.RF.R2_8.n18)=1.21 v(xdut.vref_filt_0.RF.R2_8.n19)=1.21 v(xdut.vref_filt_0.RF.R2_8.n2)=1.21 v(xdut.vref_filt_0.RF.R2_8.n20)=1.21 v(xdut.vref_filt_0.RF.R2_8.n21)=1.21 v(xdut.vref_filt_0.RF.R2_8.n22)=1.21 v(xdut.vref_filt_0.RF.R2_8.n23)=1.21 v(xdut.vref_filt_0.RF.R2_8.n24)=1.21 v(xdut.vref_filt_0.RF.R2_8.n25)=1.21 v(xdut.vref_filt_0.RF.R2_8.n3)=1.21 v(xdut.vref_filt_0.RF.R2_8.n4)=1.21 v(xdut.vref_filt_0.RF.R2_8.n5)=1.21 v(xdut.vref_filt_0.RF.R2_8.n6)=1.21 v(xdut.vref_filt_0.RF.R2_8.n7)=1.21 v(xdut.vref_filt_0.RF.R2_8.n8)=1.21 v(xdut.vref_filt_0.RF.R2_8.n9)=1.21 v(xdut.vref_filt_0.RF.R2_8.t0)=1.21 v(xdut.vref_filt_0.RF.R2_8.t1)=1.21
* unused outputs: 1 GOhm to ground
Rnc_ua_2_ nc_ua_2_ 0 1g
Rnc_ua_3_ nc_ua_3_ 0 1g
Rnc_ua_4_ nc_ua_4_ 0 1g
Rnc_ua_5_ nc_ua_5_ 0 1g
Rnc_ua_6_ nc_ua_6_ 0 1g
Rnc_ua_7_ nc_ua_7_ 0 1g
Rnc_uio_oe_0_ nc_uio_oe_0_ 0 1g
Rnc_uio_oe_1_ nc_uio_oe_1_ 0 1g
Rnc_uio_oe_2_ nc_uio_oe_2_ 0 1g
Rnc_uio_oe_3_ nc_uio_oe_3_ 0 1g
Rnc_uio_oe_4_ nc_uio_oe_4_ 0 1g
Rnc_uio_oe_5_ nc_uio_oe_5_ 0 1g
Rnc_uio_oe_6_ nc_uio_oe_6_ 0 1g
Rnc_uio_oe_7_ nc_uio_oe_7_ 0 1g
Rnc_uio_out_0_ nc_uio_out_0_ 0 1g
Rnc_uio_out_1_ nc_uio_out_1_ 0 1g
Rnc_uio_out_2_ nc_uio_out_2_ 0 1g
Rnc_uio_out_3_ nc_uio_out_3_ 0 1g
Rnc_uio_out_6_ nc_uio_out_6_ 0 1g
Rnc_uio_out_7_ nc_uio_out_7_ 0 1g
.control
set wr_singlescale
set wr_vecnames
save v(clk) v(eoc) v(vsrc) v(pad0) v(pin1) v(cmp) v(d0) v(d1) v(d2) v(d3) v(d4) v(d5) v(d6) v(d7)
tran 2e-09 8.5e-06
wrdata ../out/m2/scen_mode1_rc.dat v(clk) v(eoc) v(vsrc) v(pad0) v(pin1) v(cmp) v(d0) v(d1) v(d2) v(d3) v(d4) v(d5) v(d6) v(d7)
quit
.endc
.end
