* I4 scenario 'fallback' on the sch netlist (generated by sim/m2/scenarios.py), tt, 27 C, 1.8 V
.lib /usr/local/share/pdk/sky130A/libs.tech/ngspice/sky130.lib.spice tt
.include /home/user/ttsky26d_analog_ADC/layout/cells/m2_top_ref.spice
.temp 27
.options reltol=1e-5 abstol=1e-12 vntol=1e-6 method=gear rshunt=1e12
xdut vdd 0 start 0 0 vdd 0 0 0 0 0 0 0 vdd 0 0 0 0 d0 d1 d2 d3 d4 d5 d6 d7 cmp eoc clk rst_n pad0 pad1 tt_um_chiranjitpatel_sar_adc
VDD vdd 0 1.8
VCLK clk 0 pulse(0 1.8 5e-07 0.5n 0.5n 5e-07 1e-06)
VRST rst_n 0 pwl(0 0 1.5u 0 1.501u 1.8)
VST start 0 pwl(0 0 1.4e-06 0 1.401e-06 1.8)
VIN vsrc 0 pwl(1.5e-06 0.6 1.1499e-05 0.6 1.15e-05 1.17 2.1499e-05 1.17)
RPAD0 vsrc pad0 500
CPAD0 pad0 0 5p
CPAD1 pad1 0 5p
RPAD1 pad1 pin1 500
VEXT ext 0 1.5
REXT ext pin1 10
CDEC pin1 0 100n
.nodeset v(xdut.vbg)=1.21 v(xdut.vbg_f)=1.21
* unused outputs: 1 GOhm to ground
.control
set wr_singlescale
set wr_vecnames
save v(clk) v(eoc) v(vsrc) v(pad0) v(pin1) v(cmp) v(d0) v(d1) v(d2) v(d3) v(d4) v(d5) v(d6) v(d7)
tran 2e-09 2.5e-05
wrdata ../out/m2/scen_fallback_sch.dat v(clk) v(eoc) v(vsrc) v(pad0) v(pin1) v(cmp) v(d0) v(d1) v(d2) v(d3) v(d4) v(d5) v(d6) v(d7)
quit
.endc
.end
