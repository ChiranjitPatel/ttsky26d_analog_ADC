* Stage 0 — PNP characterization: sky130_fd_pr__pnp_05v5_W3p40L3p40 (tt)
* Diode-connected (collector = base = 0 V), as used in the bandgap core.
* q1: one device at IE1. q8: eight devices in parallel at the same total current IE8 = IE1,
* so dVbe = Vbe(q1) - Vbe(q8) = (kT/q) ln 8 ideally (54 mV at 27 C).
* Pins: Collector Base Emitter
.lib /usr/local/share/pdk/sky130A/libs.tech/ngspice/sky130.lib.spice tt
.temp 27

IE1 0 m1 1u
VS1 m1 e1 0
F8  0 e8 VS1 1   ; IE8 = IE1 (current-controlled), so one sweep drives both
xq1  0 0 e1 sky130_fd_pr__pnp_05v5_W3p40L3p40
xq8a 0 0 e8 sky130_fd_pr__pnp_05v5_W3p40L3p40
xq8b 0 0 e8 sky130_fd_pr__pnp_05v5_W3p40L3p40
xq8c 0 0 e8 sky130_fd_pr__pnp_05v5_W3p40L3p40
xq8d 0 0 e8 sky130_fd_pr__pnp_05v5_W3p40L3p40
xq8e 0 0 e8 sky130_fd_pr__pnp_05v5_W3p40L3p40
xq8f 0 0 e8 sky130_fd_pr__pnp_05v5_W3p40L3p40
xq8g 0 0 e8 sky130_fd_pr__pnp_05v5_W3p40L3p40
xq8h 0 0 e8 sky130_fd_pr__pnp_05v5_W3p40L3p40

.control
set wr_singlescale
set wr_vecnames
* Vbe vs emitter current at 27 C (both branches swept together)
dc IE1 0.1u 20u 0.1u
wrdata ../out/devices/pnp_i.dat v(e1) v(e8)
* Vbe and dVbe vs temperature at 1 uA
alter IE1 dc = 1u
dc temp -40 125 1
wrdata ../out/devices/pnp_t.dat v(e1) v(e8)
quit
.endc
.end
