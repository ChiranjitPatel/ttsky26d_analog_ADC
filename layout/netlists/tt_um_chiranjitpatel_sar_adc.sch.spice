* LVS reference for the M2 top level (generated by layout/m2_top.py)
.include /usr/local/share/pdk/sky130A/libs.ref/sky130_fd_sc_hd/spice/sky130_fd_sc_hd.spice
.subckt bias_gen VDPWR VGND pd nbias pbias
*.iopin VDPWR
*.iopin VGND
*.ipin pd
*.opin nbias
*.opin pbias
XMP1 nbias pbias VDPWR VDPWR sky130_fd_pr__pfet_01v8_lvt L=2 W=2 nf=1 ad=0.58 as=0.58 pd=4.58 ps=4.58 nrd=0.145 nrs=0.145 sa=0
+ sb=0 sd=0 mult=1
XMP2 pbias pbias VDPWR VDPWR sky130_fd_pr__pfet_01v8_lvt L=2 W=2 nf=1 ad=0.58 as=0.58 pd=4.58 ps=4.58 nrd=0.145 nrs=0.145 sa=0
+ sb=0 sd=0 mult=1
XMN1 nbias nbias VGND VGND sky130_fd_pr__nfet_01v8 L=2 W=2 nf=1 ad=0.58 as=0.58 pd=4.58 ps=4.58 nrd=0.145 nrs=0.145 sa=0 sb=0 sd=0
+ mult=1
XMN2 pbias nbias nr VGND sky130_fd_pr__nfet_01v8 L=2 W=2 nf=1 ad=0.58 as=0.58 pd=4.58 ps=4.58 nrd=0.145 nrs=0.145 sa=0 sb=0 sd=0
+ mult=4 m=4
XR1A r1m nr VGND sky130_fd_pr__res_xhigh_po_0p35 L=5.45 mult=1
XR1B VGND r1m VGND sky130_fd_pr__res_xhigh_po_0p35 L=5.45 mult=1
XMDN1 VGND VGND VGND VGND sky130_fd_pr__nfet_01v8 L=2 W=2 nf=1 ad=0.58 as=0.58 pd=4.58 ps=4.58 nrd=0.145 nrs=0.145 sa=0 sb=0 sd=0
+ mult=1
XMDN2 VGND VGND VGND VGND sky130_fd_pr__nfet_01v8 L=2 W=2 nf=1 ad=0.58 as=0.58 pd=4.58 ps=4.58 nrd=0.145 nrs=0.145 sa=0 sb=0 sd=0
+ mult=1
XMDP1 VDPWR VDPWR VDPWR VDPWR sky130_fd_pr__pfet_01v8_lvt L=2 W=2 nf=1 ad=0.58 as=0.58 pd=4.58 ps=4.58 nrd=0.145 nrs=0.145 sa=0
+ sb=0 sd=0 mult=1
XMDP2 VDPWR VDPWR VDPWR VDPWR sky130_fd_pr__pfet_01v8_lvt L=2 W=2 nf=1 ad=0.58 as=0.58 pd=4.58 ps=4.58 nrd=0.145 nrs=0.145 sa=0
+ sb=0 sd=0 mult=1
XR1D1 VGND VGND VGND sky130_fd_pr__res_xhigh_po_0p35 L=5.45 mult=1
XR1D2 VGND VGND VGND sky130_fd_pr__res_xhigh_po_0p35 L=5.45 mult=1
XMS2A ms2_1 VGND sup VDPWR sky130_fd_pr__pfet_01v8 L=10 W=0.42 nf=1 ad=0.1218 as=0.1218 pd=1.42 ps=1.42 nrd=0.69047619047619
+ nrs=0.69047619047619 sa=0 sb=0 sd=0 mult=1
XMS2B su VGND ms2_1 VDPWR sky130_fd_pr__pfet_01v8 L=10 W=0.42 nf=1 ad=0.1218 as=0.1218 pd=1.42 ps=1.42 nrd=0.69047619047619
+ nrs=0.69047619047619 sa=0 sb=0 sd=0 mult=1
XMS3 su nbias VGND VGND sky130_fd_pr__nfet_01v8 L=2 W=4 nf=1 ad=1.16 as=1.16 pd=8.58 ps=8.58 nrd=0.0725 nrs=0.0725 sa=0 sb=0 sd=0
+ mult=1
XMS1 pbias su VGND VGND sky130_fd_pr__nfet_01v8 L=1 W=0.42 nf=1 ad=0.1218 as=0.1218 pd=1.42 ps=1.42 nrd=0.69047619047619
+ nrs=0.69047619047619 sa=0 sb=0 sd=0 mult=1
XMPD2 sup pd VDPWR VDPWR sky130_fd_pr__pfet_01v8 L=1 W=0.42 nf=1 ad=0.1218 as=0.1218 pd=1.42 ps=1.42 nrd=0.69047619047619
+ nrs=0.69047619047619 sa=0 sb=0 sd=0 mult=1
XMPD1 pbias pdb VDPWR VDPWR sky130_fd_pr__pfet_01v8 L=1 W=0.42 nf=1 ad=0.1218 as=0.1218 pd=1.42 ps=1.42 nrd=0.69047619047619
+ nrs=0.69047619047619 sa=0 sb=0 sd=0 mult=1
XMND1 nbias pd VGND VGND sky130_fd_pr__nfet_01v8 L=1 W=0.42 nf=1 ad=0.1218 as=0.1218 pd=1.42 ps=1.42 nrd=0.69047619047619
+ nrs=0.69047619047619 sa=0 sb=0 sd=0 mult=1
XMND2 su pd VGND VGND sky130_fd_pr__nfet_01v8 L=1 W=0.42 nf=1 ad=0.1218 as=0.1218 pd=1.42 ps=1.42 nrd=0.69047619047619
+ nrs=0.69047619047619 sa=0 sb=0 sd=0 mult=1
XMIP pdb pd VDPWR VDPWR sky130_fd_pr__pfet_01v8 L=1 W=0.84 nf=1 ad=0.2436 as=0.2436 pd=2.26 ps=2.26 nrd=0.345238095238095
+ nrs=0.345238095238095 sa=0 sb=0 sd=0 mult=1
XMIN pdb pd VGND VGND sky130_fd_pr__nfet_01v8 L=1 W=0.42 nf=1 ad=0.1218 as=0.1218 pd=1.42 ps=1.42 nrd=0.69047619047619
+ nrs=0.69047619047619 sa=0 sb=0 sd=0 mult=1
.ends
.subckt bandgap_core VDPWR VGND pbias pd vbg vgp
*.iopin VDPWR
*.iopin VGND
*.ipin pbias
*.ipin pd
*.opin vbg
*.opin vgp
XMDS1 VDPWR VDPWR VDPWR VDPWR sky130_fd_pr__pfet_01v8 L=1 W=16 nf=1 ad=4.64 as=4.64 pd=32.58 ps=32.58 nrd=0.018125 nrs=0.018125
+ sa=0 sb=0 sd=0 mult=1
XMDS2 VDPWR VDPWR VDPWR VDPWR sky130_fd_pr__pfet_01v8 L=1 W=16 nf=1 ad=4.64 as=4.64 pd=32.58 ps=32.58 nrd=0.018125 nrs=0.018125
+ sa=0 sb=0 sd=0 mult=1
XMPA va vgp VDPWR VDPWR sky130_fd_pr__pfet_01v8 L=8 W=16 nf=1 ad=4.64 as=4.64 pd=32.58 ps=32.58 nrd=0.018125 nrs=0.018125 sa=0
+ sb=0 sd=0 mult=1
XMPB vb vgp VDPWR VDPWR sky130_fd_pr__pfet_01v8 L=8 W=16 nf=1 ad=4.64 as=4.64 pd=32.58 ps=32.58 nrd=0.018125 nrs=0.018125 sa=0
+ sb=0 sd=0 mult=1
XMPC vbg vgp VDPWR VDPWR sky130_fd_pr__pfet_01v8 L=8 W=16 nf=1 ad=4.64 as=4.64 pd=32.58 ps=32.58 nrd=0.018125 nrs=0.018125 sa=0
+ sb=0 sd=0 mult=1
XQ1 VGND VGND va sky130_fd_pr__pnp_05v5_W3p40L3p40 m=1 mult=1
XR1_1 r1__1 vb VGND sky130_fd_pr__res_xhigh_po_0p69 L=4 mult=1
XR1_2 vq2 r1__1 VGND sky130_fd_pr__res_xhigh_po_0p69 L=4 mult=1
XQ2 VGND VGND vq2 sky130_fd_pr__pnp_05v5_W3p40L3p40 m=8 mult=8
XR2_1 r2__1 vbg VGND sky130_fd_pr__res_xhigh_po_0p69 L=4 mult=1
XR2_2 r2__2 r2__1 VGND sky130_fd_pr__res_xhigh_po_0p69 L=4 mult=1
XR2_3 r2__3 r2__2 VGND sky130_fd_pr__res_xhigh_po_0p69 L=4 mult=1
XR2_4 r2__4 r2__3 VGND sky130_fd_pr__res_xhigh_po_0p69 L=4 mult=1
XR2_5 r2__5 r2__4 VGND sky130_fd_pr__res_xhigh_po_0p69 L=4 mult=1
XR2_6 r2__6 r2__5 VGND sky130_fd_pr__res_xhigh_po_0p69 L=4 mult=1
XR2_7 r2__7 r2__6 VGND sky130_fd_pr__res_xhigh_po_0p69 L=4 mult=1
XR2_8 r2__8 r2__7 VGND sky130_fd_pr__res_xhigh_po_0p69 L=4 mult=1
XR2_9 r2__9 r2__8 VGND sky130_fd_pr__res_xhigh_po_0p69 L=4 mult=1
XR2_10 r2__10 r2__9 VGND sky130_fd_pr__res_xhigh_po_0p69 L=4 mult=1
XR2_11 r2__11 r2__10 VGND sky130_fd_pr__res_xhigh_po_0p69 L=4 mult=1
XR2_12 r2__12 r2__11 VGND sky130_fd_pr__res_xhigh_po_0p69 L=4 mult=1
XR2_13 r2__13 r2__12 VGND sky130_fd_pr__res_xhigh_po_0p69 L=4 mult=1
XR2_14 r2__14 r2__13 VGND sky130_fd_pr__res_xhigh_po_0p69 L=4 mult=1
XR2_15 r2__15 r2__14 VGND sky130_fd_pr__res_xhigh_po_0p69 L=4 mult=1
XR2_16 r2__16 r2__15 VGND sky130_fd_pr__res_xhigh_po_0p69 L=4 mult=1
XR2_17 r2__17 r2__16 VGND sky130_fd_pr__res_xhigh_po_0p69 L=4 mult=1
XR2_18 r2__18 r2__17 VGND sky130_fd_pr__res_xhigh_po_0p69 L=4 mult=1
XR2_19 vq3 r2__18 VGND sky130_fd_pr__res_xhigh_po_0p69 L=4 mult=1
XQ3 VGND VGND vq3 sky130_fd_pr__pnp_05v5_W3p40L3p40 m=1 mult=1
XQD VGND VGND VGND sky130_fd_pr__pnp_05v5_W3p40L3p40 m=2 mult=2
XRD1 VGND VGND VGND sky130_fd_pr__res_xhigh_po_0p69 L=4 mult=1
XRD2 VGND VGND VGND sky130_fd_pr__res_xhigh_po_0p69 L=4 mult=1
xota VDPWR VGND pbias pd vb va vgp ota
XMSU2 su pbias VDPWR VDPWR sky130_fd_pr__pfet_01v8_lvt L=2 W=2 nf=1 ad=0.58 as=0.58 pd=4.58 ps=4.58 nrd=0.145 nrs=0.145 sa=0 sb=0
+ sd=0 mult=1
XMSU3 su vbg VGND VGND sky130_fd_pr__nfet_01v8 L=1 W=1 nf=1 ad=0.29 as=0.29 pd=2.58 ps=2.58 nrd=0.29 nrs=0.29 sa=0 sb=0 sd=0
+ mult=1
XMSU1 vgp su VGND VGND sky130_fd_pr__nfet_01v8 L=4 W=0.42 nf=1 ad=0.1218 as=0.1218 pd=1.42 ps=1.42 nrd=0.69047619047619
+ nrs=0.69047619047619 sa=0 sb=0 sd=0 mult=1
XMSD su pd VGND VGND sky130_fd_pr__nfet_01v8 L=1 W=0.42 nf=1 ad=0.1218 as=0.1218 pd=1.42 ps=1.42 nrd=0.69047619047619
+ nrs=0.69047619047619 sa=0 sb=0 sd=0 mult=1
.ends
.subckt ota VDPWR VGND pbias pd inp inn out
*.iopin VDPWR
*.iopin VGND
*.ipin pbias
*.ipin pd
*.ipin inp
*.ipin inn
*.opin out
XM5 tail pbias VDPWR VDPWR sky130_fd_pr__pfet_01v8_lvt L=2 W=2 nf=1 ad=0.58 as=0.58 pd=4.58 ps=4.58 nrd=0.145 nrs=0.145 sa=0 sb=0
+ sd=0 mult=2 m=2
XM1 d1 inn tail VDPWR sky130_fd_pr__pfet_01v8_lvt L=8 W=32 nf=1 ad=9.28 as=9.28 pd=64.58 ps=64.58 nrd=0.0090625 nrs=0.0090625 sa=0
+ sb=0 sd=0 mult=1
XM2 out1 inp tail VDPWR sky130_fd_pr__pfet_01v8_lvt L=8 W=32 nf=1 ad=9.28 as=9.28 pd=64.58 ps=64.58 nrd=0.0090625 nrs=0.0090625
+ sa=0 sb=0 sd=0 mult=1
XM3 d1 d1 VGND VGND sky130_fd_pr__nfet_01v8 L=16 W=4 nf=1 ad=1.16 as=1.16 pd=8.58 ps=8.58 nrd=0.0725 nrs=0.0725 sa=0 sb=0 sd=0
+ mult=1
XM4 out1 d1 VGND VGND sky130_fd_pr__nfet_01v8 L=16 W=4 nf=1 ad=1.16 as=1.16 pd=8.58 ps=8.58 nrd=0.0725 nrs=0.0725 sa=0 sb=0 sd=0
+ mult=1
XM6 out out1 VGND VGND sky130_fd_pr__nfet_01v8 L=16 W=4 nf=1 ad=1.16 as=1.16 pd=8.58 ps=8.58 nrd=0.0725 nrs=0.0725 sa=0 sb=0 sd=0
+ mult=4 m=4
XM7 out pbias VDPWR VDPWR sky130_fd_pr__pfet_01v8_lvt L=2 W=2 nf=1 ad=0.58 as=0.58 pd=4.58 ps=4.58 nrd=0.145 nrs=0.145 sa=0 sb=0
+ sd=0 mult=4 m=4
XRZA rzm out1 VGND sky130_fd_pr__res_xhigh_po_0p35 L=10.45 mult=1
XRZB cz rzm VGND sky130_fd_pr__res_xhigh_po_0p35 L=10.45 mult=1
XRZD1 VGND VGND VGND sky130_fd_pr__res_xhigh_po_0p35 L=10.45 mult=1
XRZD2 VGND VGND VGND sky130_fd_pr__res_xhigh_po_0p35 L=10.45 mult=1
XCC cz out sky130_fd_pr__cap_mim_m3_1 W=16 L=16 MF=4 m=4
XMDP1 VDPWR VDPWR VDPWR VDPWR sky130_fd_pr__pfet_01v8_lvt L=1 W=16 nf=1 ad=4.64 as=4.64 pd=32.58 ps=32.58 nrd=0.018125
+ nrs=0.018125 sa=0 sb=0 sd=0 mult=1
XMDP2 VDPWR VDPWR VDPWR VDPWR sky130_fd_pr__pfet_01v8_lvt L=1 W=16 nf=1 ad=4.64 as=4.64 pd=32.58 ps=32.58 nrd=0.018125
+ nrs=0.018125 sa=0 sb=0 sd=0 mult=1
XMPD out pdb VDPWR VDPWR sky130_fd_pr__pfet_01v8 L=1 W=0.42 nf=1 ad=0.1218 as=0.1218 pd=1.42 ps=1.42 nrd=0.69047619047619
+ nrs=0.69047619047619 sa=0 sb=0 sd=0 mult=1
XMND out1 pd VGND VGND sky130_fd_pr__nfet_01v8 L=1 W=0.42 nf=1 ad=0.1218 as=0.1218 pd=1.42 ps=1.42 nrd=0.69047619047619
+ nrs=0.69047619047619 sa=0 sb=0 sd=0 mult=1
XMIP pdb pd VDPWR VDPWR sky130_fd_pr__pfet_01v8 L=1 W=0.84 nf=1 ad=0.2436 as=0.2436 pd=2.26 ps=2.26 nrd=0.345238095238095
+ nrs=0.345238095238095 sa=0 sb=0 sd=0 mult=1
XMIN pdb pd VGND VGND sky130_fd_pr__nfet_01v8 L=1 W=0.42 nf=1 ad=0.1218 as=0.1218 pd=1.42 ps=1.42 nrd=0.69047619047619
+ nrs=0.69047619047619 sa=0 sb=0 sd=0 mult=1
.ends
.subckt vref_filt VGND vbg vbg_f
*.iopin VGND
*.ipin vbg
*.opin vbg_f
XRF_1 rf_1 vbg VGND sky130_fd_pr__res_xhigh_po_0p35 L=20 mult=1
XRF_2 rf_2 rf_1 VGND sky130_fd_pr__res_xhigh_po_0p35 L=20 mult=1
XRF_3 rf_3 rf_2 VGND sky130_fd_pr__res_xhigh_po_0p35 L=20 mult=1
XRF_4 rf_4 rf_3 VGND sky130_fd_pr__res_xhigh_po_0p35 L=20 mult=1
XRF_5 rf_5 rf_4 VGND sky130_fd_pr__res_xhigh_po_0p35 L=20 mult=1
XRF_6 rf_6 rf_5 VGND sky130_fd_pr__res_xhigh_po_0p35 L=20 mult=1
XRF_7 rf_7 rf_6 VGND sky130_fd_pr__res_xhigh_po_0p35 L=20 mult=1
XRF_8 rf_8 rf_7 VGND sky130_fd_pr__res_xhigh_po_0p35 L=20 mult=1
XRF_9 rf_9 rf_8 VGND sky130_fd_pr__res_xhigh_po_0p35 L=20 mult=1
XRF_10 rf_10 rf_9 VGND sky130_fd_pr__res_xhigh_po_0p35 L=20 mult=1
XRF_11 rf_11 rf_10 VGND sky130_fd_pr__res_xhigh_po_0p35 L=20 mult=1
XRF_12 rf_12 rf_11 VGND sky130_fd_pr__res_xhigh_po_0p35 L=20 mult=1
XRF_13 rf_13 rf_12 VGND sky130_fd_pr__res_xhigh_po_0p35 L=20 mult=1
XRF_14 vbg_f rf_13 VGND sky130_fd_pr__res_xhigh_po_0p35 L=20 mult=1
XRFD1 VGND VGND VGND sky130_fd_pr__res_xhigh_po_0p35 L=20 mult=1
XRFD2 VGND VGND VGND sky130_fd_pr__res_xhigh_po_0p35 L=20 mult=1
XMCF VGND vbg_f VGND VGND sky130_fd_pr__nfet_01v8 L=10 W=10 nf=1 ad=2.9 as=2.9 pd=20.58 ps=20.58 nrd=0.029 nrs=0.029 sa=0 sb=0
+ sd=0 mult=7 m=7
XCM vbg_f VGND sky130_fd_pr__cap_mim_m3_1 W=21 L=30 MF=2 m=2
.ends
.subckt ptat_out VDPWR VGND vgp vptat
*.iopin VDPWR
*.iopin VGND
*.ipin vgp
*.opin vptat
XR3D1 VGND VGND VGND sky130_fd_pr__res_xhigh_po_0p69 L=4 mult=1
XR3D2 VGND VGND VGND sky130_fd_pr__res_xhigh_po_0p69 L=4 mult=1
XMPP vptat vgp VDPWR VDPWR sky130_fd_pr__pfet_01v8 L=8 W=16 nf=1 ad=4.64 as=4.64 pd=32.58 ps=32.58 nrd=0.018125 nrs=0.018125 sa=0
+ sb=0 sd=0 mult=1
XR3_1 r3_1 vptat VGND sky130_fd_pr__res_xhigh_po_0p69 L=4 mult=1
XR3_2 r3_2 r3_1 VGND sky130_fd_pr__res_xhigh_po_0p69 L=4 mult=1
XR3_3 r3_3 r3_2 VGND sky130_fd_pr__res_xhigh_po_0p69 L=4 mult=1
XR3_4 r3_4 r3_3 VGND sky130_fd_pr__res_xhigh_po_0p69 L=4 mult=1
XR3_5 r3_5 r3_4 VGND sky130_fd_pr__res_xhigh_po_0p69 L=4 mult=1
XR3_6 r3_6 r3_5 VGND sky130_fd_pr__res_xhigh_po_0p69 L=4 mult=1
XR3_7 r3_7 r3_6 VGND sky130_fd_pr__res_xhigh_po_0p69 L=4 mult=1
XR3_8 r3_8 r3_7 VGND sky130_fd_pr__res_xhigh_po_0p69 L=4 mult=1
XR3_9 r3_9 r3_8 VGND sky130_fd_pr__res_xhigh_po_0p69 L=4 mult=1
XR3_10 r3_10 r3_9 VGND sky130_fd_pr__res_xhigh_po_0p69 L=4 mult=1
XR3_11 r3_11 r3_10 VGND sky130_fd_pr__res_xhigh_po_0p69 L=4 mult=1
XR3_12 r3_12 r3_11 VGND sky130_fd_pr__res_xhigh_po_0p69 L=4 mult=1
XR3_13 r3_13 r3_12 VGND sky130_fd_pr__res_xhigh_po_0p69 L=4 mult=1
XR3_14 r3_14 r3_13 VGND sky130_fd_pr__res_xhigh_po_0p69 L=4 mult=1
XR3_15 r3_15 r3_14 VGND sky130_fd_pr__res_xhigh_po_0p69 L=4 mult=1
XR3_16 r3_16 r3_15 VGND sky130_fd_pr__res_xhigh_po_0p69 L=4 mult=1
XR3_17 r3_17 r3_16 VGND sky130_fd_pr__res_xhigh_po_0p69 L=4 mult=1
XR3_18 r3_18 r3_17 VGND sky130_fd_pr__res_xhigh_po_0p69 L=4 mult=1
XR3_19 r3_19 r3_18 VGND sky130_fd_pr__res_xhigh_po_0p69 L=4 mult=1
XR3_20 r3_20 r3_19 VGND sky130_fd_pr__res_xhigh_po_0p69 L=4 mult=1
XR3_21 r3_21 r3_20 VGND sky130_fd_pr__res_xhigh_po_0p69 L=4 mult=1
XR3_22 VGND r3_21 VGND sky130_fd_pr__res_xhigh_po_0p69 L=4 mult=1
.ends
.subckt vref_sel VDPWR VGND ref_sel vref_oe bg_pd vref pad en_buf
*.iopin VDPWR
*.iopin VGND
*.ipin ref_sel
*.ipin vref_oe
*.ipin bg_pd
*.opin en_buf
*.iopin vref
*.iopin pad
XMP1A nb1 ref_sel VDPWR VDPWR sky130_fd_pr__pfet_01v8 L=1 W=1.68 nf=1 ad=0.4872 as=0.4872 pd=3.94 ps=3.94 nrd=0.172619047619048
+ nrs=0.172619047619048 sa=0 sb=0 sd=0 mult=1
XMP1B en_buf bg_pd nb1 VDPWR sky130_fd_pr__pfet_01v8 L=1 W=1.68 nf=1 ad=0.4872 as=0.4872 pd=3.94 ps=3.94 nrd=0.172619047619048
+ nrs=0.172619047619048 sa=0 sb=0 sd=0 mult=1
XMN1A en_buf ref_sel VGND VGND sky130_fd_pr__nfet_01v8 L=1 W=0.42 nf=1 ad=0.1218 as=0.1218 pd=1.42 ps=1.42 nrd=0.69047619047619
+ nrs=0.69047619047619 sa=0 sb=0 sd=0 mult=1
XMN1B en_buf bg_pd VGND VGND sky130_fd_pr__nfet_01v8 L=1 W=0.42 nf=1 ad=0.1218 as=0.1218 pd=1.42 ps=1.42 nrd=0.69047619047619
+ nrs=0.69047619047619 sa=0 sb=0 sd=0 mult=1
XMP2A nb2 ref_sel VDPWR VDPWR sky130_fd_pr__pfet_01v8 L=1 W=1.68 nf=1 ad=0.4872 as=0.4872 pd=3.94 ps=3.94 nrd=0.172619047619048
+ nrs=0.172619047619048 sa=0 sb=0 sd=0 mult=1
XMP2B en_pad_b vref_oe nb2 VDPWR sky130_fd_pr__pfet_01v8 L=1 W=1.68 nf=1 ad=0.4872 as=0.4872 pd=3.94 ps=3.94 nrd=0.172619047619048
+ nrs=0.172619047619048 sa=0 sb=0 sd=0 mult=1
XMN2A en_pad_b ref_sel VGND VGND sky130_fd_pr__nfet_01v8 L=1 W=0.42 nf=1 ad=0.1218 as=0.1218 pd=1.42 ps=1.42 nrd=0.69047619047619
+ nrs=0.69047619047619 sa=0 sb=0 sd=0 mult=1
XMN2B en_pad_b vref_oe VGND VGND sky130_fd_pr__nfet_01v8 L=1 W=0.42 nf=1 ad=0.1218 as=0.1218 pd=1.42 ps=1.42 nrd=0.69047619047619
+ nrs=0.69047619047619 sa=0 sb=0 sd=0 mult=1
XMP3 en_pad en_pad_b VDPWR VDPWR sky130_fd_pr__pfet_01v8 L=1 W=0.84 nf=1 ad=0.2436 as=0.2436 pd=2.26 ps=2.26 nrd=0.345238095238095
+ nrs=0.345238095238095 sa=0 sb=0 sd=0 mult=1
XMN3 en_pad en_pad_b VGND VGND sky130_fd_pr__nfet_01v8 L=1 W=0.42 nf=1 ad=0.1218 as=0.1218 pd=1.42 ps=1.42 nrd=0.69047619047619
+ nrs=0.69047619047619 sa=0 sb=0 sd=0 mult=1
XMTGN pad en_pad vref VGND sky130_fd_pr__nfet_01v8 L=0.15 W=10 nf=1 ad=2.9 as=2.9 pd=20.58 ps=20.58 nrd=0.029 nrs=0.029 sa=0 sb=0
+ sd=0 mult=1
XMTGP pad en_pad_b vref VDPWR sky130_fd_pr__pfet_01v8_lvt L=0.35 W=20 nf=1 ad=5.8 as=5.8 pd=40.58 ps=40.58 nrd=0.0145 nrs=0.0145
+ sa=0 sb=0 sd=0 mult=1
.ends
.subckt vref_buf VDPWR VGND nbias en in vref
*.iopin VDPWR
*.iopin VGND
*.ipin nbias
*.ipin en
*.ipin in
*.opin vref
XMT tail_sw nbias VGND VGND sky130_fd_pr__nfet_01v8 L=2 W=8 nf=1 ad=2.32 as=2.32 pd=16.58 ps=16.58 nrd=0.03625 nrs=0.03625 sa=0
+ sb=0 sd=0 mult=2 m=2
XMSW tail en tail_sw VGND sky130_fd_pr__nfet_01v8 L=0.15 W=4 nf=1 ad=1.16 as=1.16 pd=8.58 ps=8.58 nrd=0.0725 nrs=0.0725 sa=0 sb=0
+ sd=0 mult=1
XM1 dm in tail VGND sky130_fd_pr__nfet_01v8 L=1 W=4 nf=1 ad=1.16 as=1.16 pd=8.58 ps=8.58 nrd=0.0725 nrs=0.0725 sa=0 sb=0 sd=0
+ mult=1
XM2 vref vref tail VGND sky130_fd_pr__nfet_01v8 L=1 W=4 nf=1 ad=1.16 as=1.16 pd=8.58 ps=8.58 nrd=0.0725 nrs=0.0725 sa=0 sb=0 sd=0
+ mult=1
XM3 dm dm VDPWR VDPWR sky130_fd_pr__pfet_01v8_lvt L=1 W=4 nf=1 ad=1.16 as=1.16 pd=8.58 ps=8.58 nrd=0.0725 nrs=0.0725 sa=0 sb=0
+ sd=0 mult=1
XM4 vref dm VDPWR VDPWR sky130_fd_pr__pfet_01v8_lvt L=1 W=4 nf=1 ad=1.16 as=1.16 pd=8.58 ps=8.58 nrd=0.0725 nrs=0.0725 sa=0 sb=0
+ sd=0 mult=1
XMPU dm en VDPWR VDPWR sky130_fd_pr__pfet_01v8 L=1 W=0.42 nf=1 ad=0.1218 as=0.1218 pd=1.42 ps=1.42 nrd=0.69047619047619
+ nrs=0.69047619047619 sa=0 sb=0 sd=0 mult=1
XMCRES VGND vref VGND VGND sky130_fd_pr__nfet_01v8 L=10 W=10 nf=1 ad=2.9 as=2.9 pd=20.58 ps=20.58 nrd=0.029 nrs=0.029 sa=0 sb=0
+ sd=0 mult=7 m=7
.ends
.subckt inmux VDPWR VGND en0 en1 en2 en3 en0b en1b en2b en3b vin vptat vbg vadc
*.iopin VDPWR
*.iopin VGND
*.ipin en0
*.ipin en1
*.ipin en2
*.ipin en3
*.ipin en0b
*.ipin en1b
*.ipin en2b
*.ipin en3b
*.ipin vin
*.ipin vptat
*.ipin vbg
*.opin vadc
XMTN0 vadc en0 vin VGND sky130_fd_pr__nfet_01v8 L=0.15 W=4 nf=1 ad=1.16 as=1.16 pd=8.58 ps=8.58 nrd=0.0725 nrs=0.0725 sa=0 sb=0
+ sd=0 mult=1
XMTP0 vadc en0b vin VDPWR sky130_fd_pr__pfet_01v8_lvt L=0.35 W=8 nf=1 ad=2.32 as=2.32 pd=16.58 ps=16.58 nrd=0.03625 nrs=0.03625
+ sa=0 sb=0 sd=0 mult=1
XMTN1 vadc en1 vptat VGND sky130_fd_pr__nfet_01v8 L=0.15 W=4 nf=1 ad=1.16 as=1.16 pd=8.58 ps=8.58 nrd=0.0725 nrs=0.0725 sa=0 sb=0
+ sd=0 mult=1
XMTP1 vadc en1b vptat VDPWR sky130_fd_pr__pfet_01v8_lvt L=0.35 W=8 nf=1 ad=2.32 as=2.32 pd=16.58 ps=16.58 nrd=0.03625 nrs=0.03625
+ sa=0 sb=0 sd=0 mult=1
XMTN2 vadc en2 vbg VGND sky130_fd_pr__nfet_01v8 L=0.15 W=4 nf=1 ad=1.16 as=1.16 pd=8.58 ps=8.58 nrd=0.0725 nrs=0.0725 sa=0 sb=0
+ sd=0 mult=1
XMTP2 vadc en2b vbg VDPWR sky130_fd_pr__pfet_01v8_lvt L=0.35 W=8 nf=1 ad=2.32 as=2.32 pd=16.58 ps=16.58 nrd=0.03625 nrs=0.03625
+ sa=0 sb=0 sd=0 mult=1
XMTN3 vadc en3 VGND VGND sky130_fd_pr__nfet_01v8 L=0.15 W=4 nf=1 ad=1.16 as=1.16 pd=8.58 ps=8.58 nrd=0.0725 nrs=0.0725 sa=0 sb=0
+ sd=0 mult=1
XMTP3 vadc en3b VGND VDPWR sky130_fd_pr__pfet_01v8_lvt L=0.35 W=8 nf=1 ad=2.32 as=2.32 pd=16.58 ps=16.58 nrd=0.03625 nrs=0.03625
+ sa=0 sb=0 sd=0 mult=1
.ends
.subckt vcm_gen VDPWR VGND pbias vcm
*.iopin VDPWR
*.iopin VGND
*.ipin pbias
*.opin vcm
XMB vcm pbias VDPWR VDPWR sky130_fd_pr__pfet_01v8_lvt L=2 W=2 nf=1 ad=0.58 as=0.58 pd=4.58 ps=4.58 nrd=0.145 nrs=0.145 sa=0 sb=0
+ sd=0 mult=10 m=10
XMD vcm vcm VGND VGND sky130_fd_pr__nfet_01v8 L=1 W=4 nf=1 ad=1.16 as=1.16 pd=8.58 ps=8.58 nrd=0.0725 nrs=0.0725 sa=0 sb=0 sd=0
+ mult=1
XMCV VGND vcm VGND VGND sky130_fd_pr__nfet_01v8 L=8 W=8 nf=1 ad=2.32 as=2.32 pd=16.58 ps=16.58 nrd=0.03625 nrs=0.03625 sa=0 sb=0
+ sd=0 mult=2 m=2
.ends
.subckt dac VDPWR VGND vref vadc smp smpb gn0 gn1 gn2 gn3 gn4 gn5 gn6 gn7 gpb0 gpb1 gpb2 gpb3 gpb4 gpb5 gpb6 gpb7 vtop
*.iopin VDPWR
*.iopin VGND
*.iopin vref
*.iopin vadc
*.ipin smp
*.ipin smpb
*.ipin gn0
*.ipin gn1
*.ipin gn2
*.ipin gn3
*.ipin gn4
*.ipin gn5
*.ipin gn6
*.ipin gn7
*.ipin gpb0
*.ipin gpb1
*.ipin gpb2
*.ipin gpb3
*.ipin gpb4
*.ipin gpb5
*.ipin gpb6
*.ipin gpb7
*.iopin vtop
xarr vtop bp7 bp6 bp5 bp4 bp3 bp2 bp1 bp0 bpt VGND cap_array
xsw VDPWR VGND vref vadc smp smpb gn0 gn1 gn2 gn3 gn4 gn5 gn6 gn7 gpb0 gpb1 gpb2 gpb3 gpb4 gpb5 gpb6 gpb7 bp0 bp1 bp2 bp3 bp4 bp5
+ bp6 bp7 bpt dac_sw_row
.ends
.subckt cap_array vtop b7 b6 b5 b4 b3 b2 b1 b0 bpt VGND
*.iopin vtop
*.iopin b7
*.iopin b6
*.iopin b5
*.iopin b4
*.iopin b3
*.iopin b2
*.iopin b1
*.iopin b0
*.iopin bpt
*.iopin VGND
XC7 vtop b7 sky130_fd_pr__cap_mim_m3_1 W=2 L=1.65 MF=128 m=128
XC6 vtop b6 sky130_fd_pr__cap_mim_m3_1 W=2 L=1.65 MF=64 m=64
XC5 vtop b5 sky130_fd_pr__cap_mim_m3_1 W=2 L=1.65 MF=32 m=32
XC4 vtop b4 sky130_fd_pr__cap_mim_m3_1 W=2 L=1.65 MF=16 m=16
XC3 vtop b3 sky130_fd_pr__cap_mim_m3_1 W=2 L=1.65 MF=8 m=8
XC2 vtop b2 sky130_fd_pr__cap_mim_m3_1 W=2 L=1.65 MF=4 m=4
XC1 vtop b1 sky130_fd_pr__cap_mim_m3_1 W=2 L=1.65 MF=2 m=2
XC0 vtop b0 sky130_fd_pr__cap_mim_m3_1 W=2 L=1.65 MF=1
XCT vtop bpt sky130_fd_pr__cap_mim_m3_1 W=2 L=1.65 MF=1
XCD VGND VGND sky130_fd_pr__cap_mim_m3_1 W=2 L=1.65 MF=32 m=32
.ends
.subckt dac_sw_row VDPWR VGND vref vadc smp smpb gn0 gn1 gn2 gn3 gn4 gn5 gn6 gn7 gpb0 gpb1 gpb2 gpb3 gpb4 gpb5 gpb6 gpb7 bp0 bp1
+ bp2 bp3 bp4 bp5 bp6 bp7 bpt
*.iopin VDPWR
*.iopin VGND
*.iopin vref
*.iopin vadc
*.ipin smp
*.ipin smpb
*.ipin gn0
*.ipin gn1
*.ipin gn2
*.ipin gn3
*.ipin gn4
*.ipin gn5
*.ipin gn6
*.ipin gn7
*.ipin gpb0
*.ipin gpb1
*.ipin gpb2
*.ipin gpb3
*.ipin gpb4
*.ipin gpb5
*.ipin gpb6
*.ipin gpb7
*.iopin bp0
*.iopin bp1
*.iopin bp2
*.iopin bp3
*.iopin bp4
*.iopin bp5
*.iopin bp6
*.iopin bp7
*.iopin bpt
xsw_bp7 VDPWR VGND vref vadc smp smpb gn7 gpb7 bp7 dac_sw
xsw_bp6 VDPWR VGND vref vadc smp smpb gn6 gpb6 bp6 dac_sw
xsw_bp5 VDPWR VGND vref vadc smp smpb gn5 gpb5 bp5 dac_sw
xsw_bp4 VDPWR VGND vref vadc smp smpb gn4 gpb4 bp4 dac_sw
xsw_bp3 VDPWR VGND vref vadc smp smpb gn3 gpb3 bp3 dac_sw
xsw_bp2 VDPWR VGND vref vadc smp smpb gn2 gpb2 bp2 dac_sw
xsw_bp1 VDPWR VGND vref vadc smp smpb gn1 gpb1 bp1 dac_sw
xsw_bp0 VDPWR VGND vref vadc smp smpb gn0 gpb0 bp0 dac_sw
xsw_bpt VDPWR VGND vref vadc smp smpb smpb VDPWR bpt dac_sw
.ends
.subckt dac_sw VDPWR VGND vref vadc smp smpb gn gpb bp
*.iopin VDPWR
*.iopin VGND
*.iopin vref
*.iopin vadc
*.ipin smp
*.ipin smpb
*.ipin gn
*.ipin gpb
*.iopin bp
XMSG bp gn VGND VGND sky130_fd_pr__nfet_01v8 L=0.15 W=1 nf=1 ad=0.29 as=0.29 pd=2.58 ps=2.58 nrd=0.29 nrs=0.29 sa=0 sb=0 sd=0
+ mult=1
XMSR bp gpb vref VDPWR sky130_fd_pr__pfet_01v8_lvt L=0.35 W=4 nf=1 ad=1.16 as=1.16 pd=8.58 ps=8.58 nrd=0.0725 nrs=0.0725 sa=0 sb=0
+ sd=0 mult=1
XMSN bp smp vadc VGND sky130_fd_pr__nfet_01v8 L=0.15 W=1 nf=1 ad=0.29 as=0.29 pd=2.58 ps=2.58 nrd=0.29 nrs=0.29 sa=0 sb=0 sd=0
+ mult=1
XMSP bp smpb vadc VDPWR sky130_fd_pr__pfet_01v8_lvt L=0.35 W=2 nf=1 ad=0.58 as=0.58 pd=4.58 ps=4.58 nrd=0.145 nrs=0.145 sa=0 sb=0
+ sd=0 mult=1
.ends
.subckt comparator VDPWR VGND pbias clkb smpt inp inn opb onb
*.iopin VDPWR
*.iopin VGND
*.ipin pbias
*.ipin clkb
*.ipin smpt
*.iopin inp
*.iopin inn
*.opin opb
*.opin onb
XMTOP inp smpt inn VGND sky130_fd_pr__nfet_01v8 L=0.15 W=2 nf=1 ad=0.58 as=0.58 pd=4.58 ps=4.58 nrd=0.145 nrs=0.145 sa=0 sb=0 sd=0
+ mult=1
XMAT pts pbias VDPWR VDPWR sky130_fd_pr__pfet_01v8_lvt L=2 W=2 nf=1 ad=0.58 as=0.58 pd=4.58 ps=4.58 nrd=0.145 nrs=0.145 sa=0 sb=0
+ sd=0 mult=4 m=4
XMA1 pan inp pts VDPWR sky130_fd_pr__pfet_01v8_lvt L=0.5 W=4 nf=1 ad=1.16 as=1.16 pd=8.58 ps=8.58 nrd=0.0725 nrs=0.0725 sa=0 sb=0
+ sd=0 mult=1
XMA2 pap inn pts VDPWR sky130_fd_pr__pfet_01v8_lvt L=0.5 W=4 nf=1 ad=1.16 as=1.16 pd=8.58 ps=8.58 nrd=0.0725 nrs=0.0725 sa=0 sb=0
+ sd=0 mult=1
XMAL1 pan pan VGND VGND sky130_fd_pr__nfet_01v8 L=8 W=0.5 nf=1 ad=0.145 as=0.145 pd=1.58 ps=1.58 nrd=0.58 nrs=0.58 sa=0 sb=0 sd=0
+ mult=1
XMAL2 pap pap VGND VGND sky130_fd_pr__nfet_01v8 L=8 W=0.5 nf=1 ad=0.145 as=0.145 pd=1.58 ps=1.58 nrd=0.58 nrs=0.58 sa=0 sb=0 sd=0
+ mult=1
XMT ts clkb VDPWR VDPWR sky130_fd_pr__pfet_01v8 L=0.15 W=4 nf=1 ad=1.16 as=1.16 pd=8.58 ps=8.58 nrd=0.0725 nrs=0.0725 sa=0 sb=0
+ sd=0 mult=1
XM1 xn pap ts VDPWR sky130_fd_pr__pfet_01v8_lvt L=0.5 W=4 nf=1 ad=1.16 as=1.16 pd=8.58 ps=8.58 nrd=0.0725 nrs=0.0725 sa=0 sb=0
+ sd=0 mult=1
XM2 xp pan ts VDPWR sky130_fd_pr__pfet_01v8_lvt L=0.5 W=4 nf=1 ad=1.16 as=1.16 pd=8.58 ps=8.58 nrd=0.0725 nrs=0.0725 sa=0 sb=0
+ sd=0 mult=1
XM3 op on xp VDPWR sky130_fd_pr__pfet_01v8 L=0.15 W=2 nf=1 ad=0.58 as=0.58 pd=4.58 ps=4.58 nrd=0.145 nrs=0.145 sa=0 sb=0 sd=0
+ mult=1
XM4 on op xn VDPWR sky130_fd_pr__pfet_01v8 L=0.15 W=2 nf=1 ad=0.58 as=0.58 pd=4.58 ps=4.58 nrd=0.145 nrs=0.145 sa=0 sb=0 sd=0
+ mult=1
XM5 op on VGND VGND sky130_fd_pr__nfet_01v8 L=0.15 W=1 nf=1 ad=0.29 as=0.29 pd=2.58 ps=2.58 nrd=0.29 nrs=0.29 sa=0 sb=0 sd=0
+ mult=1
XM6 on op VGND VGND sky130_fd_pr__nfet_01v8 L=0.15 W=1 nf=1 ad=0.29 as=0.29 pd=2.58 ps=2.58 nrd=0.29 nrs=0.29 sa=0 sb=0 sd=0
+ mult=1
XMR1 xp clkb VGND VGND sky130_fd_pr__nfet_01v8 L=0.15 W=0.42 nf=1 ad=0.1218 as=0.1218 pd=1.42 ps=1.42 nrd=0.69047619047619
+ nrs=0.69047619047619 sa=0 sb=0 sd=0 mult=1
XMR2 xn clkb VGND VGND sky130_fd_pr__nfet_01v8 L=0.15 W=0.42 nf=1 ad=0.1218 as=0.1218 pd=1.42 ps=1.42 nrd=0.69047619047619
+ nrs=0.69047619047619 sa=0 sb=0 sd=0 mult=1
XMR3 op clkb VGND VGND sky130_fd_pr__nfet_01v8 L=0.15 W=0.42 nf=1 ad=0.1218 as=0.1218 pd=1.42 ps=1.42 nrd=0.69047619047619
+ nrs=0.69047619047619 sa=0 sb=0 sd=0 mult=1
XMR4 on clkb VGND VGND sky130_fd_pr__nfet_01v8 L=0.15 W=0.42 nf=1 ad=0.1218 as=0.1218 pd=1.42 ps=1.42 nrd=0.69047619047619
+ nrs=0.69047619047619 sa=0 sb=0 sd=0 mult=1
XMCXP VDPWR xp VDPWR VDPWR sky130_fd_pr__pfet_01v8 L=1.5 W=4 nf=1 ad=1.16 as=1.16 pd=8.58 ps=8.58 nrd=0.0725 nrs=0.0725 sa=0 sb=0
+ sd=0 mult=1
XMCXN VDPWR xn VDPWR VDPWR sky130_fd_pr__pfet_01v8 L=1.5 W=4 nf=1 ad=1.16 as=1.16 pd=8.58 ps=8.58 nrd=0.0725 nrs=0.0725 sa=0 sb=0
+ sd=0 mult=1
XMIOP opb op VDPWR VDPWR sky130_fd_pr__pfet_01v8 L=0.15 W=0.84 nf=1 ad=0.2436 as=0.2436 pd=2.26 ps=2.26 nrd=0.345238095238095
+ nrs=0.345238095238095 sa=0 sb=0 sd=0 mult=1
XMION opb op VGND VGND sky130_fd_pr__nfet_01v8 L=0.15 W=0.42 nf=1 ad=0.1218 as=0.1218 pd=1.42 ps=1.42 nrd=0.69047619047619
+ nrs=0.69047619047619 sa=0 sb=0 sd=0 mult=1
XMINP onb on VDPWR VDPWR sky130_fd_pr__pfet_01v8 L=0.15 W=0.84 nf=1 ad=0.2436 as=0.2436 pd=2.26 ps=2.26 nrd=0.345238095238095
+ nrs=0.345238095238095 sa=0 sb=0 sd=0 mult=1
XMINN onb on VGND VGND sky130_fd_pr__nfet_01v8 L=0.15 W=0.42 nf=1 ad=0.1218 as=0.1218 pd=1.42 ps=1.42 nrd=0.69047619047619
+ nrs=0.69047619047619 sa=0 sb=0 sd=0 mult=1
.ends
.subckt adc_digital VDPWR VGND bg_pd clk cmp_clkb cmp_out en[0] en[1] en[2] en[3]
+ enb[0] enb[1] enb[2] enb[3] eoc gn[0] gn[1] gn[2] gn[3] gn[4] gn[5] gn[6] gn[7]
+ gpb[0] gpb[1] gpb[2] gpb[3] gpb[4] gpb[5] gpb[6] gpb[7] onb opb ref_sel rst_n smp
+ smpb smpt ui_in[0] ui_in[1] ui_in[2] ui_in[3] ui_in[4] ui_in[5] ui_in[6] ui_in[7]
+ uio_in[0] uio_in[1] uio_in[2] uio_in[3] uio_in[4] uio_in[5] uio_in[6] uio_in[7]
+ uo_out[0] uo_out[1] uo_out[2] uo_out[3] uo_out[4] uo_out[5] uo_out[6] uo_out[7]
+ vref_oe
XFILLER_12_32 VGND VGND VDPWR VDPWR sky130_fd_sc_hd__fill_1
XFILLER_9_126 VGND VGND VDPWR VDPWR sky130_fd_sc_hd__fill_1
X_131_ _192_/Q _123_/X hold37/X VGND VGND VDPWR VDPWR _192_/D sky130_fd_sc_hd__a21o_2
X_114_ smp _114_/B VGND VGND VDPWR VDPWR wire7/A sky130_fd_sc_hd__nor2_2
Xhold41 _176_/Q VGND VGND VDPWR VDPWR hold41/X sky130_fd_sc_hd__dlygate4sd3_1
Xhold30 _166_/X VGND VGND VDPWR VDPWR _185_/D sky130_fd_sc_hd__dlygate4sd3_1
XPHY_EDGE_ROW_12_Right_12 VGND VGND VDPWR VDPWR sky130_fd_sc_hd__decap_3
X_130_ _079_/S ui_in[3] VGND VGND VDPWR VDPWR bg_pd sky130_fd_sc_hd__and2b_2
X_113_ smp _113_/B VGND VGND VDPWR VDPWR wire8/A sky130_fd_sc_hd__nor2_2
XPHY_EDGE_ROW_6_Right_6 VGND VGND VDPWR VDPWR sky130_fd_sc_hd__decap_3
XTAP_TAPCELL_ROW_2_36 VGND VDPWR sky130_fd_sc_hd__tapvpwrvgnd_1
Xhold42 _181_/Q VGND VGND VDPWR VDPWR hold42/X sky130_fd_sc_hd__dlygate4sd3_1
Xhold31 _187_/Q VGND VGND VDPWR VDPWR hold31/X sky130_fd_sc_hd__dlygate4sd3_1
Xhold20 _195_/Q VGND VGND VDPWR VDPWR _127_/A sky130_fd_sc_hd__dlygate4sd3_1
XFILLER_10_105 VGND VGND VDPWR VDPWR sky130_fd_sc_hd__fill_1
XTAP_TAPCELL_ROW_12_56 VGND VDPWR sky130_fd_sc_hd__tapvpwrvgnd_1
X_189_ _189_/CLK _189_/D fanout17/X VGND VGND VDPWR VDPWR _189_/Q sky130_fd_sc_hd__dfrtp_2
XPHY_EDGE_ROW_12_Left_27 VGND VGND VDPWR VDPWR sky130_fd_sc_hd__decap_3
X_112_ smpb _120_/B VGND VGND VDPWR VDPWR gpb[7] sky130_fd_sc_hd__nand2_2
Xhold43 _178_/Q VGND VGND VDPWR VDPWR hold43/X sky130_fd_sc_hd__dlygate4sd3_1
Xhold32 _168_/X VGND VGND VDPWR VDPWR _187_/D sky130_fd_sc_hd__dlygate4sd3_1
Xhold21 _127_/Y VGND VGND VDPWR VDPWR _191_/D sky130_fd_sc_hd__dlygate4sd3_1
XTAP_TAPCELL_ROW_2_37 VGND VDPWR sky130_fd_sc_hd__tapvpwrvgnd_1
XPHY_EDGE_ROW_0_Left_15 VGND VGND VDPWR VDPWR sky130_fd_sc_hd__decap_3
XTAP_TAPCELL_ROW_12_57 VGND VDPWR sky130_fd_sc_hd__tapvpwrvgnd_1
X_111_ _081_/B ui_in[7] _182_/Q _096_/X VGND VGND VDPWR VDPWR _120_/B sky130_fd_sc_hd__a22o_2
X_188_ _189_/CLK _188_/D fanout17/X VGND VGND VDPWR VDPWR _188_/Q sky130_fd_sc_hd__dfrtp_2
Xhold44 _175_/Q VGND VGND VDPWR VDPWR hold44/X sky130_fd_sc_hd__dlygate4sd3_1
Xhold33 _188_/Q VGND VGND VDPWR VDPWR hold33/X sky130_fd_sc_hd__dlygate4sd3_1
Xhold22 _190_/Q VGND VGND VDPWR VDPWR hold22/X sky130_fd_sc_hd__dlygate4sd3_1
XFILLER_11_3 VGND VGND VDPWR VDPWR sky130_fd_sc_hd__fill_1
XFILLER_12_25 VGND VGND VDPWR VDPWR sky130_fd_sc_hd__decap_3
Xu_drv.u_lq opb u_drv.u_lq/B VGND VGND VDPWR VDPWR _071_/A sky130_fd_sc_hd__nand2_1
XFILLER_13_90 VGND VGND VDPWR VDPWR sky130_fd_sc_hd__fill_1
XTAP_TAPCELL_ROW_8_48 VGND VDPWR sky130_fd_sc_hd__tapvpwrvgnd_1
Xmax_cap9 _120_/A VGND VGND VDPWR VDPWR smp sky130_fd_sc_hd__buf_6
X_187_ _189_/CLK _187_/D fanout17/X VGND VGND VDPWR VDPWR _187_/Q sky130_fd_sc_hd__dfrtp_2
X_110_ smpb _119_/B VGND VGND VDPWR VDPWR gpb[6] sky130_fd_sc_hd__nand2_2
Xhold45 _182_/Q VGND VGND VDPWR VDPWR hold45/X sky130_fd_sc_hd__dlygate4sd3_1
Xhold34 _169_/X VGND VGND VDPWR VDPWR _188_/D sky130_fd_sc_hd__dlygate4sd3_1
Xhold23 _171_/X VGND VGND VDPWR VDPWR _190_/D sky130_fd_sc_hd__dlygate4sd3_1
Xclkload0 _192_/CLK VGND VGND VDPWR VDPWR clkload0/Y sky130_fd_sc_hd__clkinv_2
XTAP_TAPCELL_ROW_8_49 VGND VDPWR sky130_fd_sc_hd__tapvpwrvgnd_1
X_068__18 _195_/CLK VGND VGND VDPWR VDPWR _196_/CLK sky130_fd_sc_hd__inv_2
Xclkload1 _189_/CLK VGND VGND VDPWR VDPWR clkload1/Y sky130_fd_sc_hd__bufinv_16
X_186_ _189_/CLK _186_/D fanout15/X VGND VGND VDPWR VDPWR _186_/Q sky130_fd_sc_hd__dfrtp_2
Xhold46 _179_/Q VGND VGND VDPWR VDPWR hold46/X sky130_fd_sc_hd__dlygate4sd3_1
Xhold35 _186_/Q VGND VGND VDPWR VDPWR hold35/X sky130_fd_sc_hd__dlygate4sd3_1
Xhold24 _183_/Q VGND VGND VDPWR VDPWR hold24/X sky130_fd_sc_hd__dlygate4sd3_1
X_169_ _180_/Q hold33/X _171_/S VGND VGND VDPWR VDPWR _169_/X sky130_fd_sc_hd__mux2_1
XFILLER_5_102 VGND VGND VDPWR VDPWR sky130_fd_sc_hd__fill_2
XPHY_EDGE_ROW_4_Left_19 VGND VGND VDPWR VDPWR sky130_fd_sc_hd__decap_3
X_068__19 _195_/CLK VGND VGND VDPWR VDPWR _121_/B1 sky130_fd_sc_hd__inv_2
X_185_ _194_/CLK _185_/D fanout16/X VGND VGND VDPWR VDPWR _185_/Q sky130_fd_sc_hd__dfrtp_2
X_099_ _081_/B ui_in[1] _176_/Q _096_/X VGND VGND VDPWR VDPWR _114_/B sky130_fd_sc_hd__a22o_2
Xhold36 _167_/X VGND VGND VDPWR VDPWR _186_/D sky130_fd_sc_hd__dlygate4sd3_1
Xhold25 _189_/Q VGND VGND VDPWR VDPWR hold25/X sky130_fd_sc_hd__dlygate4sd3_1
Xclkload2 _194_/CLK VGND VGND VDPWR VDPWR clkload2/Y sky130_fd_sc_hd__bufinv_16
X_168_ _179_/Q hold31/X _171_/S VGND VGND VDPWR VDPWR _168_/X sky130_fd_sc_hd__mux2_1
XPHY_EDGE_ROW_1_Right_1 VGND VGND VDPWR VDPWR sky130_fd_sc_hd__decap_3
XPHY_EDGE_ROW_7_Left_22 VGND VGND VDPWR VDPWR sky130_fd_sc_hd__decap_3
XTAP_TAPCELL_ROW_0_30 VGND VDPWR sky130_fd_sc_hd__tapvpwrvgnd_1
XTAP_TAPCELL_ROW_9_50 VGND VDPWR sky130_fd_sc_hd__tapvpwrvgnd_1
X_184_ _189_/CLK _184_/D fanout15/X VGND VGND VDPWR VDPWR _184_/Q sky130_fd_sc_hd__dfrtp_2
X_098_ smpb _113_/B VGND VGND VDPWR VDPWR gpb[0] sky130_fd_sc_hd__nand2_2
Xhold37 _193_/Q VGND VGND VDPWR VDPWR hold37/X sky130_fd_sc_hd__dlygate4sd3_1
Xhold26 _170_/X VGND VGND VDPWR VDPWR _189_/D sky130_fd_sc_hd__dlygate4sd3_1
X_167_ _178_/Q hold35/X _171_/S VGND VGND VDPWR VDPWR _167_/X sky130_fd_sc_hd__mux2_1
XFILLER_7_95 VGND VGND VDPWR VDPWR sky130_fd_sc_hd__fill_1
Xclkbuf_0_clk clk VGND VGND VDPWR VDPWR clkbuf_0_clk/X sky130_fd_sc_hd__clkbuf_16
XFILLER_12_29 VGND VGND VDPWR VDPWR sky130_fd_sc_hd__decap_3
XFILLER_1_97 VGND VGND VDPWR VDPWR sky130_fd_sc_hd__fill_1
XTAP_TAPCELL_ROW_0_31 VGND VDPWR sky130_fd_sc_hd__tapvpwrvgnd_1
XTAP_TAPCELL_ROW_9_51 VGND VDPWR sky130_fd_sc_hd__tapvpwrvgnd_1
X_097_ _080_/S ui_in[0] _175_/Q _096_/X VGND VGND VDPWR VDPWR _113_/B sky130_fd_sc_hd__a22o_2
X_183_ _194_/CLK _183_/D fanout16/X VGND VGND VDPWR VDPWR _183_/Q sky130_fd_sc_hd__dfrtp_2
X_166_ _177_/Q hold29/X _171_/S VGND VGND VDPWR VDPWR _166_/X sky130_fd_sc_hd__mux2_1
XFILLER_10_51 VGND VGND VDPWR VDPWR sky130_fd_sc_hd__fill_1
X_149_ _160_/B _071_/A _155_/D _146_/D _067_/Y VGND VGND VDPWR VDPWR _149_/X sky130_fd_sc_hd__a41o_2
Xhold38 _180_/Q VGND VGND VDPWR VDPWR hold38/X sky130_fd_sc_hd__dlygate4sd3_1
Xhold27 _184_/Q VGND VGND VDPWR VDPWR hold27/X sky130_fd_sc_hd__dlygate4sd3_1
XFILLER_4_75 VGND VGND VDPWR VDPWR sky130_fd_sc_hd__fill_2
XTAP_TAPCELL_ROW_0_32 VGND VDPWR sky130_fd_sc_hd__tapvpwrvgnd_1
Xclkbuf_2_0__f_clk clkbuf_0_clk/X VGND VGND VDPWR VDPWR _192_/CLK sky130_fd_sc_hd__clkbuf_16
X_182_ _194_/CLK _182_/D fanout16/X VGND VGND VDPWR VDPWR _182_/Q sky130_fd_sc_hd__dfrtp_2
XTAP_TAPCELL_ROW_10_52 VGND VDPWR sky130_fd_sc_hd__tapvpwrvgnd_1
X_096_ _080_/S _192_/Q VGND VGND VDPWR VDPWR _096_/X sky130_fd_sc_hd__and2b_2
X_148_ hold41/X _141_/Y _147_/X _146_/X VGND VGND VDPWR VDPWR _176_/D sky130_fd_sc_hd__a31o_2
Xhold39 _192_/Q VGND VGND VDPWR VDPWR hold39/X sky130_fd_sc_hd__dlygate4sd3_1
Xhold28 _165_/X VGND VGND VDPWR VDPWR _184_/D sky130_fd_sc_hd__dlygate4sd3_1
X_165_ _176_/Q hold27/X _171_/S VGND VGND VDPWR VDPWR _165_/X sky130_fd_sc_hd__mux2_1
XPHY_EDGE_ROW_5_Right_5 VGND VGND VDPWR VDPWR sky130_fd_sc_hd__decap_3
X_079_ _189_/Q ui_in[6] _079_/S VGND VGND VDPWR VDPWR uo_out[6] sky130_fd_sc_hd__mux2_1
XFILLER_4_10 VGND VGND VDPWR VDPWR sky130_fd_sc_hd__fill_1
XFILLER_1_120 VGND VGND VDPWR VDPWR sky130_fd_sc_hd__fill_1
XTAP_TAPCELL_ROW_0_33 VGND VDPWR sky130_fd_sc_hd__tapvpwrvgnd_1
X_095_ smp VGND VGND VDPWR VDPWR smpb sky130_fd_sc_hd__inv_2
X_181_ _192_/CLK _181_/D fanout15/X VGND VGND VDPWR VDPWR _181_/Q sky130_fd_sc_hd__dfrtp_2
X_164_ _071_/Y hold24/X _171_/S VGND VGND VDPWR VDPWR _183_/D sky130_fd_sc_hd__mux2_1
XPHY_EDGE_ROW_11_Left_26 VGND VGND VDPWR VDPWR sky130_fd_sc_hd__decap_3
XTAP_TAPCELL_ROW_10_53 VGND VDPWR sky130_fd_sc_hd__tapvpwrvgnd_1
X_078_ _188_/Q ui_in[5] _079_/S VGND VGND VDPWR VDPWR uo_out[5] sky130_fd_sc_hd__mux2_1
X_147_ _173_/Q _158_/B _174_/Q _160_/C VGND VGND VDPWR VDPWR _147_/X sky130_fd_sc_hd__or4_2
Xhold29 _185_/Q VGND VGND VDPWR VDPWR hold29/X sky130_fd_sc_hd__dlygate4sd3_1
XPHY_EDGE_ROW_11_Right_11 VGND VGND VDPWR VDPWR sky130_fd_sc_hd__decap_3
XFILLER_4_66 VGND VGND VDPWR VDPWR sky130_fd_sc_hd__fill_2
X_180_ _189_/CLK _180_/D fanout15/X VGND VGND VDPWR VDPWR _180_/Q sky130_fd_sc_hd__dfrtp_2
XFILLER_1_12 VGND VGND VDPWR VDPWR sky130_fd_sc_hd__fill_1
XFILLER_1_34 VGND VGND VDPWR VDPWR sky130_fd_sc_hd__fill_1
XFILLER_1_9 VGND VGND VDPWR VDPWR sky130_fd_sc_hd__decap_3
X_094_ _080_/S _193_/Q _150_/B _081_/Y VGND VGND VDPWR VDPWR _120_/A sky130_fd_sc_hd__o31a_2
X_163_ _163_/A _163_/B VGND VGND VDPWR VDPWR _182_/D sky130_fd_sc_hd__or2_2
XTAP_TAPCELL_ROW_6_44 VGND VDPWR sky130_fd_sc_hd__tapvpwrvgnd_1
X_077_ _187_/Q ui_in[4] _079_/S VGND VGND VDPWR VDPWR uo_out[4] sky130_fd_sc_hd__mux2_1
X_129_ _079_/S ui_in[1] VGND VGND VDPWR VDPWR vref_oe sky130_fd_sc_hd__and2b_2
X_146_ _192_/Q _160_/B _155_/D _146_/D VGND VGND VDPWR VDPWR _146_/X sky130_fd_sc_hd__and4_2
XFILLER_13_32 VGND VGND VDPWR VDPWR sky130_fd_sc_hd__decap_3
XFILLER_8_3 VGND VGND VDPWR VDPWR sky130_fd_sc_hd__decap_3
X_093_ _194_/Q _191_/Q VGND VGND VDPWR VDPWR _150_/B sky130_fd_sc_hd__or2_2
Xfanout11 _173_/Q VGND VGND VDPWR VDPWR _158_/A sky130_fd_sc_hd__clkdlybuf4s25_1
X_162_ _160_/B _153_/B _160_/C hold45/X VGND VGND VDPWR VDPWR _163_/B sky130_fd_sc_hd__o31a_2
XTAP_TAPCELL_ROW_6_45 VGND VDPWR sky130_fd_sc_hd__tapvpwrvgnd_1
X_076_ _186_/Q ui_in[3] _079_/S VGND VGND VDPWR VDPWR uo_out[3] sky130_fd_sc_hd__mux2_1
X_145_ _143_/Y _144_/X _163_/A VGND VGND VDPWR VDPWR _175_/D sky130_fd_sc_hd__a21oi_2
XPHY_EDGE_ROW_9_Right_9 VGND VGND VDPWR VDPWR sky130_fd_sc_hd__decap_3
X_128_ _080_/S ui_in[0] VGND VGND VDPWR VDPWR _195_/D sky130_fd_sc_hd__and2b_2
XFILLER_13_66 VGND VGND VDPWR VDPWR sky130_fd_sc_hd__decap_3
Xfanout12 uio_in[0] VGND VGND VDPWR VDPWR _080_/S sky130_fd_sc_hd__clkdlybuf4s25_1
X_092_ _194_/Q _191_/Q VGND VGND VDPWR VDPWR _155_/D sky130_fd_sc_hd__nor2_2
X_161_ hold42/X _141_/Y _160_/X _152_/X _134_/X VGND VGND VDPWR VDPWR _181_/D sky130_fd_sc_hd__a32o_2
XFILLER_7_57 VGND VGND VDPWR VDPWR sky130_fd_sc_hd__fill_2
X_075_ _185_/Q ui_in[2] _080_/S VGND VGND VDPWR VDPWR uo_out[2] sky130_fd_sc_hd__mux2_1
X_127_ _127_/A _155_/D VGND VGND VDPWR VDPWR _127_/Y sky130_fd_sc_hd__nor2_2
X_144_ _173_/Q _158_/B _174_/Q _150_/B VGND VGND VDPWR VDPWR _144_/X sky130_fd_sc_hd__or4_2
XFILLER_12_125 VGND VGND VDPWR VDPWR sky130_fd_sc_hd__fill_2
XPHY_EDGE_ROW_3_Left_18 VGND VGND VDPWR VDPWR sky130_fd_sc_hd__decap_3
Xfanout13 uio_in[0] VGND VGND VDPWR VDPWR _081_/B sky130_fd_sc_hd__clkdlybuf4s25_1
X_074_ _184_/Q ui_in[1] _080_/S VGND VGND VDPWR VDPWR uo_out[1] sky130_fd_sc_hd__mux2_1
X_091_ enb[3] VGND VGND VDPWR VDPWR en[3] sky130_fd_sc_hd__inv_2
X_143_ _123_/X _160_/C hold44/X VGND VGND VDPWR VDPWR _143_/Y sky130_fd_sc_hd__o21ai_2
X_160_ _172_/Q _160_/B _160_/C _158_/A VGND VGND VDPWR VDPWR _160_/X sky130_fd_sc_hd__or4b_2
XPHY_EDGE_ROW_0_Right_0 VGND VGND VDPWR VDPWR sky130_fd_sc_hd__decap_3
XPHY_EDGE_ROW_6_Left_21 VGND VGND VDPWR VDPWR sky130_fd_sc_hd__decap_3
X_126_ _127_/A _150_/B VGND VGND VDPWR VDPWR _193_/D sky130_fd_sc_hd__and2_2
XFILLER_8_6 VGND VGND VDPWR VDPWR sky130_fd_sc_hd__fill_1
X_109_ _079_/S ui_in[6] _181_/Q _096_/X VGND VGND VDPWR VDPWR _119_/B sky130_fd_sc_hd__a22o_2
Xfanout14 uio_in[0] VGND VGND VDPWR VDPWR _079_/S sky130_fd_sc_hd__clkdlybuf4s25_1
X_090_ uio_in[7] uio_in[6] VGND VGND VDPWR VDPWR enb[3] sky130_fd_sc_hd__nand2_2
Xclkbuf_2_1__f_clk clkbuf_0_clk/X VGND VGND VDPWR VDPWR _189_/CLK sky130_fd_sc_hd__clkbuf_16
X_073_ _183_/Q ui_in[0] _080_/S VGND VGND VDPWR VDPWR uo_out[0] sky130_fd_sc_hd__mux2_1
X_125_ _171_/S VGND VGND VDPWR VDPWR _194_/D sky130_fd_sc_hd__inv_2
X_142_ _194_/Q _191_/Q _071_/A VGND VGND VDPWR VDPWR _160_/C sky130_fd_sc_hd__or3b_2
XFILLER_8_80 VGND VGND VDPWR VDPWR sky130_fd_sc_hd__fill_1
XTAP_TAPCELL_ROW_3_38 VGND VDPWR sky130_fd_sc_hd__tapvpwrvgnd_1
X_108_ smpb _118_/B VGND VGND VDPWR VDPWR gpb[5] sky130_fd_sc_hd__nand2_2
XFILLER_1_104 VGND VGND VDPWR VDPWR sky130_fd_sc_hd__fill_1
XFILLER_4_49 VGND VGND VDPWR VDPWR sky130_fd_sc_hd__fill_2
XTAP_TAPCELL_ROW_13_58 VGND VDPWR sky130_fd_sc_hd__tapvpwrvgnd_1
Xfanout15 fanout17/X VGND VGND VDPWR VDPWR fanout15/X sky130_fd_sc_hd__clkdlybuf4s25_1
XFILLER_10_26 VGND VGND VDPWR VDPWR sky130_fd_sc_hd__fill_2
X_072_ _079_/S _194_/Q VGND VGND VDPWR VDPWR eoc sky130_fd_sc_hd__and2b_2
X_141_ _141_/A _155_/D VGND VGND VDPWR VDPWR _141_/Y sky130_fd_sc_hd__nand2_2
XFILLER_2_93 VGND VGND VDPWR VDPWR sky130_fd_sc_hd__fill_1
XTAP_TAPCELL_ROW_3_39 VGND VDPWR sky130_fd_sc_hd__tapvpwrvgnd_1
X_124_ _158_/A _172_/Q _174_/Q _192_/Q VGND VGND VDPWR VDPWR _171_/S sky130_fd_sc_hd__or4b_2
XTAP_TAPCELL_ROW_13_59 VGND VDPWR sky130_fd_sc_hd__tapvpwrvgnd_1
X_107_ _079_/S ui_in[5] _180_/Q _096_/X VGND VGND VDPWR VDPWR _118_/B sky130_fd_sc_hd__a22o_2
Xfanout16 fanout17/X VGND VGND VDPWR VDPWR fanout16/X sky130_fd_sc_hd__clkdlybuf4s25_1
XPHY_EDGE_ROW_14_Right_14 VGND VGND VDPWR VDPWR sky130_fd_sc_hd__decap_3
X_071_ _071_/A VGND VGND VDPWR VDPWR _071_/Y sky130_fd_sc_hd__inv_2
X_140_ _192_/Q _150_/B VGND VGND VDPWR VDPWR _163_/A sky130_fd_sc_hd__nor2_2
XFILLER_11_70 VGND VGND VDPWR VDPWR sky130_fd_sc_hd__fill_1
XFILLER_8_71 VGND VGND VDPWR VDPWR sky130_fd_sc_hd__fill_1
XPHY_EDGE_ROW_4_Right_4 VGND VGND VDPWR VDPWR sky130_fd_sc_hd__decap_3
X_106_ smpb _117_/B VGND VGND VDPWR VDPWR gpb[4] sky130_fd_sc_hd__nand2_2
X_123_ _158_/A _172_/Q _174_/Q VGND VGND VDPWR VDPWR _123_/X sky130_fd_sc_hd__or3_2
Xfanout17 rst_n VGND VGND VDPWR VDPWR fanout17/X sky130_fd_sc_hd__clkdlybuf4s25_1
X_070_ _174_/Q VGND VGND VDPWR VDPWR _160_/B sky130_fd_sc_hd__inv_2
XFILLER_11_60 VGND VGND VDPWR VDPWR sky130_fd_sc_hd__fill_1
XPHY_EDGE_ROW_10_Left_25 VGND VGND VDPWR VDPWR sky130_fd_sc_hd__decap_3
X_122_ _158_/A _172_/Q VGND VGND VDPWR VDPWR _122_/Y sky130_fd_sc_hd__nor2_2
XTAP_TAPCELL_ROW_4_40 VGND VDPWR sky130_fd_sc_hd__tapvpwrvgnd_1
X_105_ _079_/S ui_in[4] _179_/Q _096_/X VGND VGND VDPWR VDPWR _117_/B sky130_fd_sc_hd__a22o_2
XFILLER_5_84 VGND VGND VDPWR VDPWR sky130_fd_sc_hd__decap_3
XTAP_TAPCELL_ROW_14_60 VGND VDPWR sky130_fd_sc_hd__tapvpwrvgnd_1
XFILLER_10_29 VGND VGND VDPWR VDPWR sky130_fd_sc_hd__fill_2
X_104_ smpb _116_/B VGND VGND VDPWR VDPWR gpb[3] sky130_fd_sc_hd__nand2_2
X_121_ _080_/S uio_in[2] _121_/B1 _096_/X VGND VGND VDPWR VDPWR cmp_clkb sky130_fd_sc_hd__a22oi_2
XFILLER_13_29 VGND VGND VDPWR VDPWR sky130_fd_sc_hd__decap_3
XTAP_TAPCELL_ROW_4_41 VGND VDPWR sky130_fd_sc_hd__tapvpwrvgnd_1
XFILLER_14_50 VGND VGND VDPWR VDPWR sky130_fd_sc_hd__decap_3
XFILLER_14_83 VGND VGND VDPWR VDPWR sky130_fd_sc_hd__fill_1
XTAP_TAPCELL_ROW_14_61 VGND VDPWR sky130_fd_sc_hd__tapvpwrvgnd_1
XPHY_EDGE_ROW_10_Right_10 VGND VGND VDPWR VDPWR sky130_fd_sc_hd__decap_3
X_120_ _120_/A _120_/B VGND VGND VDPWR VDPWR wire1/A sky130_fd_sc_hd__nor2_2
X_197_ uio_in[3] VGND VGND VDPWR VDPWR ref_sel sky130_fd_sc_hd__buf_2
X_103_ _081_/B ui_in[3] _178_/Q _096_/X VGND VGND VDPWR VDPWR _116_/B sky130_fd_sc_hd__a22o_2
XFILLER_5_75 VGND VGND VDPWR VDPWR sky130_fd_sc_hd__fill_2
XPHY_EDGE_ROW_8_Right_8 VGND VGND VDPWR VDPWR sky130_fd_sc_hd__decap_3
XTAP_TAPCELL_ROW_14_62 VGND VDPWR sky130_fd_sc_hd__tapvpwrvgnd_1
X_196_ _196_/CLK _196_/D fanout16/X VGND VGND VDPWR VDPWR _196_/Q sky130_fd_sc_hd__dfstp_2
XFILLER_11_30 VGND VGND VDPWR VDPWR sky130_fd_sc_hd__fill_1
XFILLER_7_126 VGND VGND VDPWR VDPWR sky130_fd_sc_hd__fill_1
X_102_ smpb _115_/B VGND VGND VDPWR VDPWR gpb[2] sky130_fd_sc_hd__nand2_2
Xclkbuf_2_2__f_clk clkbuf_0_clk/X VGND VGND VDPWR VDPWR _195_/CLK sky130_fd_sc_hd__clkbuf_16
X_179_ _192_/CLK _179_/D fanout15/X VGND VGND VDPWR VDPWR _179_/Q sky130_fd_sc_hd__dfrtp_2
XPHY_EDGE_ROW_14_Left_29 VGND VGND VDPWR VDPWR sky130_fd_sc_hd__decap_3
XTAP_TAPCELL_ROW_14_63 VGND VDPWR sky130_fd_sc_hd__tapvpwrvgnd_1
XPHY_EDGE_ROW_2_Left_17 VGND VGND VDPWR VDPWR sky130_fd_sc_hd__decap_3
X_195_ _195_/CLK _195_/D fanout16/X VGND VGND VDPWR VDPWR _195_/Q sky130_fd_sc_hd__dfrtp_2
XPHY_EDGE_ROW_5_Left_20 VGND VGND VDPWR VDPWR sky130_fd_sc_hd__decap_3
X_101_ _081_/B ui_in[2] _177_/Q _096_/X VGND VGND VDPWR VDPWR _115_/B sky130_fd_sc_hd__a22o_2
X_178_ _192_/CLK _178_/D fanout15/X VGND VGND VDPWR VDPWR _178_/Q sky130_fd_sc_hd__dfrtp_2
XFILLER_14_53 VGND VGND VDPWR VDPWR sky130_fd_sc_hd__decap_3
XTAP_TAPCELL_ROW_1_34 VGND VDPWR sky130_fd_sc_hd__tapvpwrvgnd_1
Xwire1 wire1/A VGND VGND VDPWR VDPWR gn[7] sky130_fd_sc_hd__clkbuf_4
X_194_ _194_/CLK _194_/D fanout17/X VGND VGND VDPWR VDPWR _194_/Q sky130_fd_sc_hd__dfrtp_2
XTAP_TAPCELL_ROW_11_54 VGND VDPWR sky130_fd_sc_hd__tapvpwrvgnd_1
X_100_ smpb _114_/B VGND VGND VDPWR VDPWR gpb[1] sky130_fd_sc_hd__nand2_2
X_177_ _195_/CLK _177_/D fanout16/X VGND VGND VDPWR VDPWR _177_/Q sky130_fd_sc_hd__dfrtp_2
XFILLER_3_120 VGND VGND VDPWR VDPWR sky130_fd_sc_hd__fill_1
Xu_drv.u_lqb onb _071_/A VGND VGND VDPWR VDPWR u_drv.u_lq/B sky130_fd_sc_hd__nand2_1
XTAP_TAPCELL_ROW_1_35 VGND VDPWR sky130_fd_sc_hd__tapvpwrvgnd_1
XFILLER_11_55 VGND VGND VDPWR VDPWR sky130_fd_sc_hd__fill_1
XTAP_TAPCELL_ROW_11_55 VGND VDPWR sky130_fd_sc_hd__tapvpwrvgnd_1
Xwire2 wire2/A VGND VGND VDPWR VDPWR gn[6] sky130_fd_sc_hd__clkbuf_4
X_193_ _195_/CLK _193_/D fanout16/X VGND VGND VDPWR VDPWR _193_/Q sky130_fd_sc_hd__dfrtp_2
XFILLER_0_3 VGND VGND VDPWR VDPWR sky130_fd_sc_hd__decap_3
X_176_ _194_/CLK _176_/D fanout15/X VGND VGND VDPWR VDPWR _176_/Q sky130_fd_sc_hd__dfrtp_2
X_159_ hold38/X _141_/Y _158_/X _152_/X _146_/D VGND VGND VDPWR VDPWR _180_/D sky130_fd_sc_hd__a32o_2
XFILLER_5_57 VGND VGND VDPWR VDPWR sky130_fd_sc_hd__fill_2
Xwire3 wire3/A VGND VGND VDPWR VDPWR gn[5] sky130_fd_sc_hd__clkbuf_4
X_192_ _192_/CLK _192_/D fanout16/X VGND VGND VDPWR VDPWR _192_/Q sky130_fd_sc_hd__dfrtp_2
XTAP_TAPCELL_ROW_7_46 VGND VDPWR sky130_fd_sc_hd__tapvpwrvgnd_1
X_175_ _195_/CLK _175_/D fanout16/X VGND VGND VDPWR VDPWR _175_/Q sky130_fd_sc_hd__dfrtp_2
XFILLER_8_68 VGND VGND VDPWR VDPWR sky130_fd_sc_hd__decap_3
XPHY_EDGE_ROW_9_Left_24 VGND VGND VDPWR VDPWR sky130_fd_sc_hd__decap_3
X_089_ enb[2] VGND VGND VDPWR VDPWR en[2] sky130_fd_sc_hd__inv_2
X_158_ _158_/A _158_/B _160_/B _160_/C VGND VGND VDPWR VDPWR _158_/X sky130_fd_sc_hd__or4_2
XPHY_EDGE_ROW_3_Right_3 VGND VGND VDPWR VDPWR sky130_fd_sc_hd__decap_3
XFILLER_11_57 VGND VGND VDPWR VDPWR sky130_fd_sc_hd__decap_3
Xwire4 wire4/A VGND VGND VDPWR VDPWR gn[4] sky130_fd_sc_hd__clkbuf_4
X_191_ _195_/CLK _191_/D fanout16/X VGND VGND VDPWR VDPWR _191_/Q sky130_fd_sc_hd__dfstp_2
XTAP_TAPCELL_ROW_7_47 VGND VDPWR sky130_fd_sc_hd__tapvpwrvgnd_1
X_088_ uio_in[6] uio_in[7] VGND VGND VDPWR VDPWR enb[2] sky130_fd_sc_hd__nand2b_2
X_174_ _192_/CLK _174_/D fanout15/X VGND VGND VDPWR VDPWR _174_/Q sky130_fd_sc_hd__dfstp_2
X_157_ _155_/X _156_/X _141_/Y VGND VGND VDPWR VDPWR _179_/D sky130_fd_sc_hd__o21a_2
XFILLER_14_57 VGND VGND VDPWR VDPWR sky130_fd_sc_hd__fill_1
XPHY_EDGE_ROW_13_Right_13 VGND VGND VDPWR VDPWR sky130_fd_sc_hd__decap_3
Xwire5 wire5/A VGND VGND VDPWR VDPWR gn[3] sky130_fd_sc_hd__clkbuf_4
XFILLER_2_9 VGND VGND VDPWR VDPWR sky130_fd_sc_hd__fill_1
X_190_ _194_/CLK _190_/D fanout17/X VGND VGND VDPWR VDPWR _190_/Q sky130_fd_sc_hd__dfrtp_2
X_173_ _192_/CLK _173_/D fanout15/X VGND VGND VDPWR VDPWR _173_/Q sky130_fd_sc_hd__dfstp_2
XFILLER_0_6 VGND VGND VDPWR VDPWR sky130_fd_sc_hd__fill_1
XFILLER_11_106 VGND VGND VDPWR VDPWR sky130_fd_sc_hd__fill_1
X_087_ enb[1] VGND VGND VDPWR VDPWR en[1] sky130_fd_sc_hd__inv_2
Xwire10 _071_/A VGND VGND VDPWR VDPWR cmp_out sky130_fd_sc_hd__clkbuf_4
X_156_ _158_/A _160_/B _160_/C hold46/X VGND VGND VDPWR VDPWR _156_/X sky130_fd_sc_hd__o31a_2
XFILLER_10_8 VGND VGND VDPWR VDPWR sky130_fd_sc_hd__fill_1
X_139_ hold39/X _122_/Y _138_/Y VGND VGND VDPWR VDPWR _139_/Y sky130_fd_sc_hd__a21oi_2
Xclkbuf_2_3__f_clk clkbuf_0_clk/X VGND VGND VDPWR VDPWR _194_/CLK sky130_fd_sc_hd__clkbuf_16
Xwire6 wire6/A VGND VGND VDPWR VDPWR gn[2] sky130_fd_sc_hd__clkbuf_4
X_086_ uio_in[7] uio_in[6] VGND VGND VDPWR VDPWR enb[1] sky130_fd_sc_hd__nand2b_2
X_155_ _158_/A _172_/Q _174_/Q _155_/D VGND VGND VDPWR VDPWR _155_/X sky130_fd_sc_hd__and4b_2
X_172_ _192_/CLK _172_/D fanout15/X VGND VGND VDPWR VDPWR _172_/Q sky130_fd_sc_hd__dfstp_2
X_069_ _172_/Q VGND VGND VDPWR VDPWR _158_/B sky130_fd_sc_hd__inv_2
X_138_ hold37/X _141_/A _174_/Q VGND VGND VDPWR VDPWR _138_/Y sky130_fd_sc_hd__a21oi_2
XPHY_EDGE_ROW_7_Right_7 VGND VGND VDPWR VDPWR sky130_fd_sc_hd__decap_3
Xwire7 wire7/A VGND VGND VDPWR VDPWR gn[1] sky130_fd_sc_hd__clkbuf_4
X_171_ _182_/Q hold22/X _171_/S VGND VGND VDPWR VDPWR _171_/X sky130_fd_sc_hd__mux2_1
XFILLER_3_50 VGND VGND VDPWR VDPWR sky130_fd_sc_hd__fill_1
X_085_ enb[0] VGND VGND VDPWR VDPWR en[0] sky130_fd_sc_hd__inv_2
X_154_ hold43/X _141_/Y _153_/X _152_/X _122_/Y VGND VGND VDPWR VDPWR _178_/D sky130_fd_sc_hd__a32o_2
XFILLER_0_118 VGND VGND VDPWR VDPWR sky130_fd_sc_hd__fill_1
XFILLER_0_62 VGND VGND VDPWR VDPWR sky130_fd_sc_hd__fill_1
XPHY_EDGE_ROW_13_Left_28 VGND VGND VDPWR VDPWR sky130_fd_sc_hd__decap_3
X_137_ _141_/A _122_/Y _134_/X _132_/X _158_/A VGND VGND VDPWR VDPWR _173_/D sky130_fd_sc_hd__o32a_2
Xwire8 wire8/A VGND VGND VDPWR VDPWR gn[0] sky130_fd_sc_hd__clkbuf_4
XPHY_EDGE_ROW_1_Left_16 VGND VGND VDPWR VDPWR sky130_fd_sc_hd__decap_3
X_170_ _181_/Q hold25/X _171_/S VGND VGND VDPWR VDPWR _170_/X sky130_fd_sc_hd__mux2_1
XFILLER_0_85 VGND VGND VDPWR VDPWR sky130_fd_sc_hd__fill_1
XFILLER_8_29 VGND VGND VDPWR VDPWR sky130_fd_sc_hd__fill_1
X_067_ _177_/Q VGND VGND VDPWR VDPWR _067_/Y sky130_fd_sc_hd__inv_2
X_084_ uio_in[7] uio_in[6] VGND VGND VDPWR VDPWR enb[0] sky130_fd_sc_hd__or2_2
X_136_ _172_/Q _158_/A VGND VGND VDPWR VDPWR _146_/D sky130_fd_sc_hd__and2b_2
X_153_ _174_/Q _153_/B _160_/C VGND VGND VDPWR VDPWR _153_/X sky130_fd_sc_hd__or3_2
X_119_ _120_/A _119_/B VGND VGND VDPWR VDPWR wire2/A sky130_fd_sc_hd__nor2_2
XFILLER_3_63 VGND VGND VDPWR VDPWR sky130_fd_sc_hd__fill_1
XFILLER_3_74 VGND VGND VDPWR VDPWR sky130_fd_sc_hd__fill_2
X_083_ _193_/Q _192_/Q VGND VGND VDPWR VDPWR _196_/D sky130_fd_sc_hd__nor2_2
X_152_ _192_/Q _174_/Q _155_/D VGND VGND VDPWR VDPWR _152_/X sky130_fd_sc_hd__and3_2
X_066_ _192_/Q VGND VGND VDPWR VDPWR _141_/A sky130_fd_sc_hd__inv_2
X_118_ _120_/A _118_/B VGND VGND VDPWR VDPWR wire3/A sky130_fd_sc_hd__nor2_2
X_135_ _173_/Q _172_/Q VGND VGND VDPWR VDPWR _153_/B sky130_fd_sc_hd__nand2_2
XFILLER_14_29 VGND VGND VDPWR VDPWR sky130_fd_sc_hd__decap_3
XFILLER_6_74 VGND VGND VDPWR VDPWR sky130_fd_sc_hd__fill_1
X_082_ _080_/S _196_/Q _081_/Y VGND VGND VDPWR VDPWR smpt sky130_fd_sc_hd__o21a_2
X_134_ _158_/A _172_/Q VGND VGND VDPWR VDPWR _134_/X sky130_fd_sc_hd__and2_2
X_151_ _149_/X _150_/X _163_/A VGND VGND VDPWR VDPWR _177_/D sky130_fd_sc_hd__a21oi_2
XTAP_TAPCELL_ROW_5_42 VGND VDPWR sky130_fd_sc_hd__tapvpwrvgnd_1
X_117_ _120_/A _117_/B VGND VGND VDPWR VDPWR wire4/A sky130_fd_sc_hd__nor2_2
X_081_ uio_in[1] _081_/B VGND VGND VDPWR VDPWR _081_/Y sky130_fd_sc_hd__nand2b_2
X_150_ _174_/Q _150_/B _153_/B VGND VGND VDPWR VDPWR _150_/X sky130_fd_sc_hd__or3_2
XFILLER_9_53 VGND VGND VDPWR VDPWR sky130_fd_sc_hd__decap_3
XPHY_EDGE_ROW_8_Left_23 VGND VGND VDPWR VDPWR sky130_fd_sc_hd__decap_3
X_133_ _141_/A _132_/X _158_/B VGND VGND VDPWR VDPWR _172_/D sky130_fd_sc_hd__mux2_1
XFILLER_6_65 VGND VGND VDPWR VDPWR sky130_fd_sc_hd__fill_1
XPHY_EDGE_ROW_2_Right_2 VGND VGND VDPWR VDPWR sky130_fd_sc_hd__decap_3
XTAP_TAPCELL_ROW_5_43 VGND VDPWR sky130_fd_sc_hd__tapvpwrvgnd_1
X_116_ smp _116_/B VGND VGND VDPWR VDPWR wire5/A sky130_fd_sc_hd__nor2_2
X_080_ _190_/Q ui_in[7] _080_/S VGND VGND VDPWR VDPWR uo_out[7] sky130_fd_sc_hd__mux2_1
X_132_ _196_/D _171_/S VGND VGND VDPWR VDPWR _132_/X sky130_fd_sc_hd__and2b_2
X_115_ smp _115_/B VGND VGND VDPWR VDPWR wire6/A sky130_fd_sc_hd__nor2_2
Xhold40 _139_/Y VGND VGND VDPWR VDPWR _174_/D sky130_fd_sc_hd__dlygate4sd3_1
.ends

.subckt tt_um_chiranjitpatel_sar_adc VDPWR VGND ui_in[0] ui_in[1] ui_in[2] ui_in[3] ui_in[4] ui_in[5] ui_in[6] ui_in[7] uio_in[0] uio_in[1] uio_in[2] uio_in[3] uio_in[4] uio_in[5] uio_in[6] uio_in[7] uo_out[0] uo_out[1] uo_out[2] uo_out[3] uo_out[4] uo_out[5] uo_out[6] uo_out[7] uio_out[4] uio_out[5] clk rst_n ua[0] ua[1]
xb VDPWR VGND VGND nbias pbias bias_gen
xbg VDPWR VGND pbias bg_pd vbg vgp bandgap_core
xpt VDPWR VGND vgp vptat ptat_out
xf VGND vbg vbg_f vref_filt
xbuf VDPWR VGND nbias en_buf vbg_f vref vref_buf
xsel VDPWR VGND ref_sel vref_oe bg_pd vref ua[1] en_buf vref_sel
xmux VDPWR VGND en0 en1 en2 en3 en0b en1b en2b en3b ua[0] vptat vbg vadc inmux
xvcm VDPWR VGND pbias vcm vcm_gen
xdac VDPWR VGND vref vadc smp smpb gn0 gn1 gn2 gn3 gn4 gn5 gn6 gn7 gpb0 gpb1 gpb2 gpb3 gpb4 gpb5 gpb6 gpb7 vtop dac
xcmp VDPWR VGND pbias cmp_clkb smpt vtop vcm opb onb comparator
xdig VDPWR VGND bg_pd clk cmp_clkb uio_out[4] en0 en1 en2 en3 en0b en1b en2b en3b uio_out[5] gn0 gn1 gn2 gn3 gn4 gn5 gn6 gn7 gpb0 gpb1 gpb2 gpb3 gpb4 gpb5 gpb6 gpb7 onb opb ref_sel rst_n smp smpb smpt ui_in[0] ui_in[1] ui_in[2] ui_in[3] ui_in[4] ui_in[5] ui_in[6] ui_in[7] uio_in[0] uio_in[1] uio_in[2] uio_in[3] uio_in[4] uio_in[5] uio_in[6] uio_in[7] uo_out[0] uo_out[1] uo_out[2] uo_out[3] uo_out[4] uo_out[5] uo_out[6] uo_out[7] vref_oe adc_digital
.ends
