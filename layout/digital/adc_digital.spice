* NGSPICE file created from adc_digital.ext - technology: sky130A

* Black-box entry subcircuit for sky130_fd_sc_hd__fill_1 abstract view
.subckt sky130_fd_sc_hd__fill_1 VGND VNB VPB VPWR
.ends

* Black-box entry subcircuit for sky130_fd_sc_hd__a21o_2 abstract view
.subckt sky130_fd_sc_hd__a21o_2 A1 A2 B1 VGND VNB VPB VPWR X
.ends

* Black-box entry subcircuit for sky130_fd_sc_hd__fill_2 abstract view
.subckt sky130_fd_sc_hd__fill_2 VGND VNB VPB VPWR
.ends

* Black-box entry subcircuit for sky130_fd_sc_hd__nor2_2 abstract view
.subckt sky130_fd_sc_hd__nor2_2 A B VGND VNB VPB VPWR Y
.ends

* Black-box entry subcircuit for sky130_fd_sc_hd__dlygate4sd3_1 abstract view
.subckt sky130_fd_sc_hd__dlygate4sd3_1 A VGND VNB VPB VPWR X
.ends

* Black-box entry subcircuit for sky130_fd_sc_hd__decap_3 abstract view
.subckt sky130_fd_sc_hd__decap_3 VGND VNB VPB VPWR
.ends

* Black-box entry subcircuit for sky130_fd_sc_hd__and2b_2 abstract view
.subckt sky130_fd_sc_hd__and2b_2 A_N B VGND VNB VPB VPWR X
.ends

* Black-box entry subcircuit for sky130_fd_sc_hd__tapvpwrvgnd_1 abstract view
.subckt sky130_fd_sc_hd__tapvpwrvgnd_1 VGND VPWR
.ends

* Black-box entry subcircuit for sky130_fd_sc_hd__dfrtp_2 abstract view
.subckt sky130_fd_sc_hd__dfrtp_2 CLK D RESET_B VGND VNB VPB VPWR Q
.ends

* Black-box entry subcircuit for sky130_fd_sc_hd__nand2_2 abstract view
.subckt sky130_fd_sc_hd__nand2_2 A B VGND VNB VPB VPWR Y
.ends

* Black-box entry subcircuit for sky130_fd_sc_hd__a22o_2 abstract view
.subckt sky130_fd_sc_hd__a22o_2 A1 A2 B1 B2 VGND VNB VPB VPWR X
.ends

* Black-box entry subcircuit for sky130_fd_sc_hd__nand2_1 abstract view
.subckt sky130_fd_sc_hd__nand2_1 A B VGND VNB VPB VPWR Y
.ends

* Black-box entry subcircuit for sky130_fd_sc_hd__buf_6 abstract view
.subckt sky130_fd_sc_hd__buf_6 A VGND VNB VPB VPWR X
.ends

* Black-box entry subcircuit for sky130_fd_sc_hd__clkinv_2 abstract view
.subckt sky130_fd_sc_hd__clkinv_2 A VGND VNB VPB VPWR Y
.ends

* Black-box entry subcircuit for sky130_fd_sc_hd__inv_2 abstract view
.subckt sky130_fd_sc_hd__inv_2 A VGND VNB VPB VPWR Y
.ends

* Black-box entry subcircuit for sky130_fd_sc_hd__bufinv_16 abstract view
.subckt sky130_fd_sc_hd__bufinv_16 A VGND VNB VPB VPWR Y
.ends

* Black-box entry subcircuit for sky130_fd_sc_hd__mux2_1 abstract view
.subckt sky130_fd_sc_hd__mux2_1 A0 A1 S VGND VNB VPB VPWR X
.ends

* Black-box entry subcircuit for sky130_fd_sc_hd__clkbuf_16 abstract view
.subckt sky130_fd_sc_hd__clkbuf_16 A VGND VNB VPB VPWR X
.ends

* Black-box entry subcircuit for sky130_fd_sc_hd__a41o_2 abstract view
.subckt sky130_fd_sc_hd__a41o_2 A1 A2 A3 A4 B1 VGND VNB VPB VPWR X
.ends

* Black-box entry subcircuit for sky130_fd_sc_hd__a31o_2 abstract view
.subckt sky130_fd_sc_hd__a31o_2 A1 A2 A3 B1 VGND VNB VPB VPWR X
.ends

* Black-box entry subcircuit for sky130_fd_sc_hd__or4_2 abstract view
.subckt sky130_fd_sc_hd__or4_2 A B C D VGND VNB VPB VPWR X
.ends

* Black-box entry subcircuit for sky130_fd_sc_hd__o31a_2 abstract view
.subckt sky130_fd_sc_hd__o31a_2 A1 A2 A3 B1 VGND VNB VPB VPWR X
.ends

* Black-box entry subcircuit for sky130_fd_sc_hd__or2_2 abstract view
.subckt sky130_fd_sc_hd__or2_2 A B VGND VNB VPB VPWR X
.ends

* Black-box entry subcircuit for sky130_fd_sc_hd__and4_2 abstract view
.subckt sky130_fd_sc_hd__and4_2 A B C D VGND VNB VPB VPWR X
.ends

* Black-box entry subcircuit for sky130_fd_sc_hd__clkdlybuf4s25_1 abstract view
.subckt sky130_fd_sc_hd__clkdlybuf4s25_1 A VGND VNB VPB VPWR X
.ends

* Black-box entry subcircuit for sky130_fd_sc_hd__a21oi_2 abstract view
.subckt sky130_fd_sc_hd__a21oi_2 A1 A2 B1 VGND VNB VPB VPWR Y
.ends

* Black-box entry subcircuit for sky130_fd_sc_hd__a32o_2 abstract view
.subckt sky130_fd_sc_hd__a32o_2 A1 A2 A3 B1 B2 VGND VNB VPB VPWR X
.ends

* Black-box entry subcircuit for sky130_fd_sc_hd__o21ai_2 abstract view
.subckt sky130_fd_sc_hd__o21ai_2 A1 A2 B1 VGND VNB VPB VPWR Y
.ends

* Black-box entry subcircuit for sky130_fd_sc_hd__or4b_2 abstract view
.subckt sky130_fd_sc_hd__or4b_2 A B C D_N VGND VNB VPB VPWR X
.ends

* Black-box entry subcircuit for sky130_fd_sc_hd__and2_2 abstract view
.subckt sky130_fd_sc_hd__and2_2 A B VGND VNB VPB VPWR X
.ends

* Black-box entry subcircuit for sky130_fd_sc_hd__or3b_2 abstract view
.subckt sky130_fd_sc_hd__or3b_2 A B C_N VGND VNB VPB VPWR X
.ends

* Black-box entry subcircuit for sky130_fd_sc_hd__or3_2 abstract view
.subckt sky130_fd_sc_hd__or3_2 A B C VGND VNB VPB VPWR X
.ends

* Black-box entry subcircuit for sky130_fd_sc_hd__a22oi_2 abstract view
.subckt sky130_fd_sc_hd__a22oi_2 A1 A2 B1 B2 VGND VNB VPB VPWR Y
.ends

* Black-box entry subcircuit for sky130_fd_sc_hd__buf_2 abstract view
.subckt sky130_fd_sc_hd__buf_2 A VGND VNB VPB VPWR X
.ends

* Black-box entry subcircuit for sky130_fd_sc_hd__dfstp_2 abstract view
.subckt sky130_fd_sc_hd__dfstp_2 CLK D SET_B VGND VNB VPB VPWR Q
.ends

* Black-box entry subcircuit for sky130_fd_sc_hd__clkbuf_4 abstract view
.subckt sky130_fd_sc_hd__clkbuf_4 A VGND VNB VPB VPWR X
.ends

* Black-box entry subcircuit for sky130_fd_sc_hd__nand2b_2 abstract view
.subckt sky130_fd_sc_hd__nand2b_2 A_N B VGND VNB VPB VPWR Y
.ends

* Black-box entry subcircuit for sky130_fd_sc_hd__o21a_2 abstract view
.subckt sky130_fd_sc_hd__o21a_2 A1 A2 B1 VGND VNB VPB VPWR X
.ends

* Black-box entry subcircuit for sky130_fd_sc_hd__and4b_2 abstract view
.subckt sky130_fd_sc_hd__and4b_2 A_N B C D VGND VNB VPB VPWR X
.ends

* Black-box entry subcircuit for sky130_fd_sc_hd__o32a_2 abstract view
.subckt sky130_fd_sc_hd__o32a_2 A1 A2 A3 B1 B2 VGND VNB VPB VPWR X
.ends

* Black-box entry subcircuit for sky130_fd_sc_hd__nor2_1 abstract view
.subckt sky130_fd_sc_hd__nor2_1 A B VGND VNB VPB VPWR Y
.ends

* Black-box entry subcircuit for sky130_fd_sc_hd__and3_2 abstract view
.subckt sky130_fd_sc_hd__and3_2 A B C VGND VNB VPB VPWR X
.ends

.subckt adc_digital VDPWR VGND bg_pd clk cmp_clkb cmp_out en[0] en[1] en[2] en[3]
+ enb[0] enb[1] enb[2] enb[3] eoc gn[0] gn[1] gn[2] gn[3] gn[4] gn[5] gn[6] gn[7]
+ gpb[0] gpb[1] gpb[2] gpb[3] gpb[4] gpb[5] gpb[6] gpb[7] onb opb ref_sel rst_n smp
+ smpb smpt ui_in[0] ui_in[1] ui_in[2] ui_in[3] ui_in[4] ui_in[5] ui_in[6] ui_in[7]
+ uio_in[0] uio_in[1] uio_in[2] uio_in[3] uio_in[4] uio_in[5] uio_in[6] uio_in[7]
+ uo_out[0] uo_out[1] uo_out[2] uo_out[3] uo_out[4] uo_out[5] uo_out[6] uo_out[7]
+ vref_oe
XFILLER_9_126 VGND VGND VDPWR VDPWR sky130_fd_sc_hd__fill_1
X_131_ _192_/Q _123_/X hold39/X VGND VGND VDPWR VDPWR _192_/D sky130_fd_sc_hd__a21o_2
XFILLER_13_3 VGND VGND VDPWR VDPWR sky130_fd_sc_hd__fill_2
X_114_ _120_/A _114_/B VGND VGND VDPWR VDPWR wire7/A sky130_fd_sc_hd__nor2_2
Xhold41 _180_/Q VGND VGND VDPWR VDPWR hold41/X sky130_fd_sc_hd__dlygate4sd3_1
Xhold30 _189_/Q VGND VGND VDPWR VDPWR hold30/X sky130_fd_sc_hd__dlygate4sd3_1
XPHY_EDGE_ROW_12_Right_12 VGND VGND VDPWR VDPWR sky130_fd_sc_hd__decap_3
X_130_ _081_/B ui_in[3] VGND VGND VDPWR VDPWR bg_pd sky130_fd_sc_hd__and2b_2
XFILLER_9_34 VGND VGND VDPWR VDPWR sky130_fd_sc_hd__fill_1
X_113_ _120_/A _113_/B VGND VGND VDPWR VDPWR wire8/A sky130_fd_sc_hd__nor2_2
XPHY_EDGE_ROW_6_Right_6 VGND VGND VDPWR VDPWR sky130_fd_sc_hd__decap_3
XTAP_TAPCELL_ROW_2_36 VGND VDPWR sky130_fd_sc_hd__tapvpwrvgnd_1
Xhold42 _176_/Q VGND VGND VDPWR VDPWR hold42/X sky130_fd_sc_hd__dlygate4sd3_1
Xhold31 _170_/X VGND VGND VDPWR VDPWR _189_/D sky130_fd_sc_hd__dlygate4sd3_1
Xhold20 _195_/Q VGND VGND VDPWR VDPWR _127_/A sky130_fd_sc_hd__dlygate4sd3_1
XFILLER_3_47 VGND VGND VDPWR VDPWR sky130_fd_sc_hd__fill_2
XTAP_TAPCELL_ROW_12_56 VGND VDPWR sky130_fd_sc_hd__tapvpwrvgnd_1
XFILLER_0_15 VGND VGND VDPWR VDPWR sky130_fd_sc_hd__fill_1
X_189_ _189_/CLK _189_/D fanout17/X VGND VGND VDPWR VDPWR _189_/Q sky130_fd_sc_hd__dfrtp_2
XPHY_EDGE_ROW_12_Left_27 VGND VGND VDPWR VDPWR sky130_fd_sc_hd__decap_3
X_112_ smpb _120_/B VGND VGND VDPWR VDPWR gpb[7] sky130_fd_sc_hd__nand2_2
Xhold43 _181_/Q VGND VGND VDPWR VDPWR hold43/X sky130_fd_sc_hd__dlygate4sd3_1
Xhold32 _185_/Q VGND VGND VDPWR VDPWR hold32/X sky130_fd_sc_hd__dlygate4sd3_1
Xhold21 _127_/Y VGND VGND VDPWR VDPWR _191_/D sky130_fd_sc_hd__dlygate4sd3_1
XFILLER_13_125 VGND VGND VDPWR VDPWR sky130_fd_sc_hd__fill_2
XTAP_TAPCELL_ROW_2_37 VGND VDPWR sky130_fd_sc_hd__tapvpwrvgnd_1
XPHY_EDGE_ROW_0_Left_15 VGND VGND VDPWR VDPWR sky130_fd_sc_hd__decap_3
XTAP_TAPCELL_ROW_12_57 VGND VDPWR sky130_fd_sc_hd__tapvpwrvgnd_1
X_111_ _081_/B ui_in[7] _182_/Q _096_/X VGND VGND VDPWR VDPWR _120_/B sky130_fd_sc_hd__a22o_2
X_188_ _189_/CLK _188_/D fanout17/X VGND VGND VDPWR VDPWR _188_/Q sky130_fd_sc_hd__dfrtp_2
XFILLER_6_37 VGND VGND VDPWR VDPWR sky130_fd_sc_hd__fill_2
Xhold44 _175_/Q VGND VGND VDPWR VDPWR hold44/X sky130_fd_sc_hd__dlygate4sd3_1
Xhold33 _166_/X VGND VGND VDPWR VDPWR _185_/D sky130_fd_sc_hd__dlygate4sd3_1
Xhold22 _187_/Q VGND VGND VDPWR VDPWR hold22/X sky130_fd_sc_hd__dlygate4sd3_1
Xu_drv.u_lq opb u_drv.u_lq/B VGND VGND VDPWR VDPWR _071_/A sky130_fd_sc_hd__nand2_1
XFILLER_5_111 VGND VGND VDPWR VDPWR sky130_fd_sc_hd__fill_1
XTAP_TAPCELL_ROW_8_48 VGND VDPWR sky130_fd_sc_hd__tapvpwrvgnd_1
Xmax_cap9 smp VGND VGND VDPWR VDPWR _120_/A sky130_fd_sc_hd__buf_6
X_187_ _189_/CLK _187_/D fanout17/X VGND VGND VDPWR VDPWR _187_/Q sky130_fd_sc_hd__dfrtp_2
X_110_ smpb _119_/B VGND VGND VDPWR VDPWR gpb[6] sky130_fd_sc_hd__nand2_2
Xhold45 _182_/Q VGND VGND VDPWR VDPWR hold45/X sky130_fd_sc_hd__dlygate4sd3_1
Xhold34 _184_/Q VGND VGND VDPWR VDPWR hold34/X sky130_fd_sc_hd__dlygate4sd3_1
Xhold23 _168_/X VGND VGND VDPWR VDPWR _187_/D sky130_fd_sc_hd__dlygate4sd3_1
Xclkload0 _181_/CLK VGND VGND VDPWR VDPWR clkload0/Y sky130_fd_sc_hd__clkinv_2
XFILLER_6_27 VGND VGND VDPWR VDPWR sky130_fd_sc_hd__fill_1
XFILLER_7_92 VGND VGND VDPWR VDPWR sky130_fd_sc_hd__fill_2
XFILLER_12_26 VGND VGND VDPWR VDPWR sky130_fd_sc_hd__fill_2
XTAP_TAPCELL_ROW_8_49 VGND VDPWR sky130_fd_sc_hd__tapvpwrvgnd_1
X_068__18 _195_/CLK VGND VGND VDPWR VDPWR _196_/CLK sky130_fd_sc_hd__inv_2
XFILLER_2_126 VGND VGND VDPWR VDPWR sky130_fd_sc_hd__fill_1
Xclkload1 _189_/CLK VGND VGND VDPWR VDPWR clkload1/Y sky130_fd_sc_hd__bufinv_16
X_186_ _189_/CLK _186_/D fanout15/X VGND VGND VDPWR VDPWR _186_/Q sky130_fd_sc_hd__dfrtp_2
Xhold46 _179_/Q VGND VGND VDPWR VDPWR hold46/X sky130_fd_sc_hd__dlygate4sd3_1
Xhold35 _165_/X VGND VGND VDPWR VDPWR _184_/D sky130_fd_sc_hd__dlygate4sd3_1
Xhold24 _188_/Q VGND VGND VDPWR VDPWR hold24/X sky130_fd_sc_hd__dlygate4sd3_1
X_169_ _180_/Q hold24/X _171_/S VGND VGND VDPWR VDPWR _169_/X sky130_fd_sc_hd__mux2_1
XPHY_EDGE_ROW_4_Left_19 VGND VGND VDPWR VDPWR sky130_fd_sc_hd__decap_3
X_068__19 _195_/CLK VGND VGND VDPWR VDPWR _121_/B1 sky130_fd_sc_hd__inv_2
X_185_ _194_/CLK _185_/D fanout16/X VGND VGND VDPWR VDPWR _185_/Q sky130_fd_sc_hd__dfrtp_2
X_099_ _079_/S ui_in[1] _176_/Q _096_/X VGND VGND VDPWR VDPWR _114_/B sky130_fd_sc_hd__a22o_2
Xhold36 _183_/Q VGND VGND VDPWR VDPWR hold36/X sky130_fd_sc_hd__dlygate4sd3_1
Xhold25 _169_/X VGND VGND VDPWR VDPWR _188_/D sky130_fd_sc_hd__dlygate4sd3_1
Xclkload2 _194_/CLK VGND VGND VDPWR VDPWR clkload2/Y sky130_fd_sc_hd__bufinv_16
X_168_ _179_/Q hold22/X _171_/S VGND VGND VDPWR VDPWR _168_/X sky130_fd_sc_hd__mux2_1
XFILLER_7_72 VGND VGND VDPWR VDPWR sky130_fd_sc_hd__fill_1
XPHY_EDGE_ROW_1_Right_1 VGND VGND VDPWR VDPWR sky130_fd_sc_hd__decap_3
XPHY_EDGE_ROW_7_Left_22 VGND VGND VDPWR VDPWR sky130_fd_sc_hd__decap_3
XFILLER_13_60 VGND VGND VDPWR VDPWR sky130_fd_sc_hd__decap_3
XFILLER_4_73 VGND VGND VDPWR VDPWR sky130_fd_sc_hd__fill_1
XTAP_TAPCELL_ROW_0_30 VGND VDPWR sky130_fd_sc_hd__tapvpwrvgnd_1
XTAP_TAPCELL_ROW_9_50 VGND VDPWR sky130_fd_sc_hd__tapvpwrvgnd_1
X_184_ _189_/CLK _184_/D fanout15/X VGND VGND VDPWR VDPWR _184_/Q sky130_fd_sc_hd__dfrtp_2
XFILLER_1_96 VGND VGND VDPWR VDPWR sky130_fd_sc_hd__fill_2
X_098_ smpb _113_/B VGND VGND VDPWR VDPWR gpb[0] sky130_fd_sc_hd__nand2_2
Xhold37 _192_/Q VGND VGND VDPWR VDPWR hold37/X sky130_fd_sc_hd__dlygate4sd3_1
Xhold26 _190_/Q VGND VGND VDPWR VDPWR hold26/X sky130_fd_sc_hd__dlygate4sd3_1
X_167_ _178_/Q hold28/X _171_/S VGND VGND VDPWR VDPWR _167_/X sky130_fd_sc_hd__mux2_1
Xclkbuf_0_clk clk VGND VGND VDPWR VDPWR clkbuf_0_clk/X sky130_fd_sc_hd__clkbuf_16
XFILLER_4_85 VGND VGND VDPWR VDPWR sky130_fd_sc_hd__fill_1
XFILLER_5_126 VGND VGND VDPWR VDPWR sky130_fd_sc_hd__fill_1
XFILLER_13_72 VGND VGND VDPWR VDPWR sky130_fd_sc_hd__fill_1
XFILLER_13_94 VGND VGND VDPWR VDPWR sky130_fd_sc_hd__decap_3
XTAP_TAPCELL_ROW_0_31 VGND VDPWR sky130_fd_sc_hd__tapvpwrvgnd_1
XTAP_TAPCELL_ROW_9_51 VGND VDPWR sky130_fd_sc_hd__tapvpwrvgnd_1
X_097_ _080_/S ui_in[0] _175_/Q _096_/X VGND VGND VDPWR VDPWR _113_/B sky130_fd_sc_hd__a22o_2
X_183_ _194_/CLK _183_/D fanout16/X VGND VGND VDPWR VDPWR _183_/Q sky130_fd_sc_hd__dfrtp_2
X_166_ _177_/Q hold32/X _171_/S VGND VGND VDPWR VDPWR _166_/X sky130_fd_sc_hd__mux2_1
X_149_ _160_/B _071_/A _155_/D _146_/D _067_/Y VGND VGND VDPWR VDPWR _149_/X sky130_fd_sc_hd__a41o_2
Xhold38 _139_/Y VGND VGND VDPWR VDPWR _174_/D sky130_fd_sc_hd__dlygate4sd3_1
Xhold27 _171_/X VGND VGND VDPWR VDPWR _190_/D sky130_fd_sc_hd__dlygate4sd3_1
XFILLER_4_64 VGND VGND VDPWR VDPWR sky130_fd_sc_hd__fill_1
XTAP_TAPCELL_ROW_0_32 VGND VDPWR sky130_fd_sc_hd__tapvpwrvgnd_1
Xclkbuf_2_0__f_clk clkbuf_0_clk/X VGND VGND VDPWR VDPWR _181_/CLK sky130_fd_sc_hd__clkbuf_16
X_182_ _194_/CLK _182_/D fanout16/X VGND VGND VDPWR VDPWR _182_/Q sky130_fd_sc_hd__dfrtp_2
XTAP_TAPCELL_ROW_10_52 VGND VDPWR sky130_fd_sc_hd__tapvpwrvgnd_1
X_096_ _080_/S _192_/Q VGND VGND VDPWR VDPWR _096_/X sky130_fd_sc_hd__and2b_2
X_148_ hold42/X _141_/Y _147_/X _146_/X VGND VGND VDPWR VDPWR _176_/D sky130_fd_sc_hd__a31o_2
Xhold39 _193_/Q VGND VGND VDPWR VDPWR hold39/X sky130_fd_sc_hd__dlygate4sd3_1
Xhold28 _186_/Q VGND VGND VDPWR VDPWR hold28/X sky130_fd_sc_hd__dlygate4sd3_1
X_165_ _176_/Q hold34/X _171_/S VGND VGND VDPWR VDPWR _165_/X sky130_fd_sc_hd__mux2_1
XPHY_EDGE_ROW_5_Right_5 VGND VGND VDPWR VDPWR sky130_fd_sc_hd__decap_3
X_079_ _189_/Q ui_in[6] _079_/S VGND VGND VDPWR VDPWR uo_out[6] sky130_fd_sc_hd__mux2_1
XTAP_TAPCELL_ROW_0_33 VGND VDPWR sky130_fd_sc_hd__tapvpwrvgnd_1
X_095_ _120_/A VGND VGND VDPWR VDPWR smpb sky130_fd_sc_hd__inv_2
X_181_ _181_/CLK _181_/D fanout15/X VGND VGND VDPWR VDPWR _181_/Q sky130_fd_sc_hd__dfrtp_2
X_164_ _071_/Y hold36/X _171_/S VGND VGND VDPWR VDPWR _183_/D sky130_fd_sc_hd__mux2_1
XPHY_EDGE_ROW_11_Left_26 VGND VGND VDPWR VDPWR sky130_fd_sc_hd__decap_3
XTAP_TAPCELL_ROW_10_53 VGND VDPWR sky130_fd_sc_hd__tapvpwrvgnd_1
X_078_ _188_/Q ui_in[5] _079_/S VGND VGND VDPWR VDPWR uo_out[5] sky130_fd_sc_hd__mux2_1
X_147_ _158_/A _158_/B _174_/Q _160_/C VGND VGND VDPWR VDPWR _147_/X sky130_fd_sc_hd__or4_2
Xhold29 _167_/X VGND VGND VDPWR VDPWR _186_/D sky130_fd_sc_hd__dlygate4sd3_1
XFILLER_12_100 VGND VGND VDPWR VDPWR sky130_fd_sc_hd__fill_1
XFILLER_8_126 VGND VGND VDPWR VDPWR sky130_fd_sc_hd__fill_1
XPHY_EDGE_ROW_11_Right_11 VGND VGND VDPWR VDPWR sky130_fd_sc_hd__decap_3
X_180_ _181_/CLK _180_/D fanout15/X VGND VGND VDPWR VDPWR _180_/Q sky130_fd_sc_hd__dfrtp_2
X_094_ _080_/S _193_/Q _150_/B _081_/Y VGND VGND VDPWR VDPWR smp sky130_fd_sc_hd__o31a_2
X_163_ _163_/A _163_/B VGND VGND VDPWR VDPWR _182_/D sky130_fd_sc_hd__or2_2
XTAP_TAPCELL_ROW_6_44 VGND VDPWR sky130_fd_sc_hd__tapvpwrvgnd_1
X_077_ _187_/Q ui_in[4] _080_/S VGND VGND VDPWR VDPWR uo_out[4] sky130_fd_sc_hd__mux2_1
X_129_ _079_/S ui_in[1] VGND VGND VDPWR VDPWR vref_oe sky130_fd_sc_hd__and2b_2
X_146_ _192_/Q _160_/B _155_/D _146_/D VGND VGND VDPWR VDPWR _146_/X sky130_fd_sc_hd__and4_2
XFILLER_4_45 VGND VGND VDPWR VDPWR sky130_fd_sc_hd__decap_3
X_093_ _194_/Q _191_/Q VGND VGND VDPWR VDPWR _150_/B sky130_fd_sc_hd__or2_2
Xfanout11 _173_/Q VGND VGND VDPWR VDPWR _158_/A sky130_fd_sc_hd__clkdlybuf4s25_1
X_162_ _160_/B _153_/B _160_/C hold45/X VGND VGND VDPWR VDPWR _163_/B sky130_fd_sc_hd__o31a_2
XFILLER_1_57 VGND VGND VDPWR VDPWR sky130_fd_sc_hd__fill_2
XTAP_TAPCELL_ROW_6_45 VGND VDPWR sky130_fd_sc_hd__tapvpwrvgnd_1
X_076_ _186_/Q ui_in[3] _079_/S VGND VGND VDPWR VDPWR uo_out[3] sky130_fd_sc_hd__mux2_1
X_145_ _143_/Y _144_/X _163_/A VGND VGND VDPWR VDPWR _175_/D sky130_fd_sc_hd__a21oi_2
XPHY_EDGE_ROW_9_Right_9 VGND VGND VDPWR VDPWR sky130_fd_sc_hd__decap_3
X_128_ _080_/S ui_in[0] VGND VGND VDPWR VDPWR _195_/D sky130_fd_sc_hd__and2b_2
Xfanout12 _081_/B VGND VGND VDPWR VDPWR _079_/S sky130_fd_sc_hd__clkdlybuf4s25_1
X_092_ _194_/Q _191_/Q VGND VGND VDPWR VDPWR _155_/D sky130_fd_sc_hd__nor2_2
X_161_ hold43/X _141_/Y _160_/X _152_/X _134_/X VGND VGND VDPWR VDPWR _181_/D sky130_fd_sc_hd__a32o_2
X_075_ _185_/Q ui_in[2] _080_/S VGND VGND VDPWR VDPWR uo_out[2] sky130_fd_sc_hd__mux2_1
X_127_ _127_/A _155_/D VGND VGND VDPWR VDPWR _127_/Y sky130_fd_sc_hd__nor2_2
X_144_ _173_/Q _158_/B _174_/Q _150_/B VGND VGND VDPWR VDPWR _144_/X sky130_fd_sc_hd__or4_2
XFILLER_12_125 VGND VGND VDPWR VDPWR sky130_fd_sc_hd__fill_2
XPHY_EDGE_ROW_3_Left_18 VGND VGND VDPWR VDPWR sky130_fd_sc_hd__decap_3
Xfanout13 _081_/B VGND VGND VDPWR VDPWR _080_/S sky130_fd_sc_hd__clkdlybuf4s25_1
X_074_ _184_/Q ui_in[1] _079_/S VGND VGND VDPWR VDPWR uo_out[1] sky130_fd_sc_hd__mux2_1
X_091_ enb[3] VGND VGND VDPWR VDPWR en[3] sky130_fd_sc_hd__inv_2
X_143_ _123_/X _160_/C hold44/X VGND VGND VDPWR VDPWR _143_/Y sky130_fd_sc_hd__o21ai_2
X_160_ _172_/Q _160_/B _160_/C _158_/A VGND VGND VDPWR VDPWR _160_/X sky130_fd_sc_hd__or4b_2
XPHY_EDGE_ROW_0_Right_0 VGND VGND VDPWR VDPWR sky130_fd_sc_hd__decap_3
XPHY_EDGE_ROW_6_Left_21 VGND VGND VDPWR VDPWR sky130_fd_sc_hd__decap_3
X_126_ _127_/A _150_/B VGND VGND VDPWR VDPWR _193_/D sky130_fd_sc_hd__and2_2
XFILLER_13_57 VGND VGND VDPWR VDPWR sky130_fd_sc_hd__decap_3
XFILLER_4_48 VGND VGND VDPWR VDPWR sky130_fd_sc_hd__fill_1
X_109_ _079_/S ui_in[6] _181_/Q _096_/X VGND VGND VDPWR VDPWR _119_/B sky130_fd_sc_hd__a22o_2
Xfanout14 uio_in[0] VGND VGND VDPWR VDPWR _081_/B sky130_fd_sc_hd__clkdlybuf4s25_1
XFILLER_6_3 VGND VGND VDPWR VDPWR sky130_fd_sc_hd__decap_3
X_090_ uio_in[7] uio_in[6] VGND VGND VDPWR VDPWR enb[3] sky130_fd_sc_hd__nand2_2
Xclkbuf_2_1__f_clk clkbuf_0_clk/X VGND VGND VDPWR VDPWR _189_/CLK sky130_fd_sc_hd__clkbuf_16
XFILLER_10_69 VGND VGND VDPWR VDPWR sky130_fd_sc_hd__fill_2
X_073_ _183_/Q ui_in[0] _080_/S VGND VGND VDPWR VDPWR uo_out[0] sky130_fd_sc_hd__mux2_1
X_125_ _171_/S VGND VGND VDPWR VDPWR _194_/D sky130_fd_sc_hd__inv_2
X_142_ _194_/Q _191_/Q _071_/A VGND VGND VDPWR VDPWR _160_/C sky130_fd_sc_hd__or3b_2
XTAP_TAPCELL_ROW_3_38 VGND VDPWR sky130_fd_sc_hd__tapvpwrvgnd_1
X_108_ smpb _118_/B VGND VGND VDPWR VDPWR gpb[5] sky130_fd_sc_hd__nand2_2
XFILLER_4_27 VGND VGND VDPWR VDPWR sky130_fd_sc_hd__fill_1
XFILLER_5_81 VGND VGND VDPWR VDPWR sky130_fd_sc_hd__fill_1
XTAP_TAPCELL_ROW_13_58 VGND VDPWR sky130_fd_sc_hd__tapvpwrvgnd_1
Xfanout15 fanout17/X VGND VGND VDPWR VDPWR fanout15/X sky130_fd_sc_hd__clkdlybuf4s25_1
XFILLER_1_39 VGND VGND VDPWR VDPWR sky130_fd_sc_hd__fill_1
X_072_ _079_/S _194_/Q VGND VGND VDPWR VDPWR eoc sky130_fd_sc_hd__and2b_2
X_141_ _141_/A _155_/D VGND VGND VDPWR VDPWR _141_/Y sky130_fd_sc_hd__nand2_2
XTAP_TAPCELL_ROW_3_39 VGND VDPWR sky130_fd_sc_hd__tapvpwrvgnd_1
X_124_ _158_/A _172_/Q _174_/Q _192_/Q VGND VGND VDPWR VDPWR _171_/S sky130_fd_sc_hd__or4b_2
XTAP_TAPCELL_ROW_13_59 VGND VDPWR sky130_fd_sc_hd__tapvpwrvgnd_1
X_107_ _079_/S ui_in[5] _180_/Q _096_/X VGND VGND VDPWR VDPWR _118_/B sky130_fd_sc_hd__a22o_2
Xfanout16 fanout17/X VGND VGND VDPWR VDPWR fanout16/X sky130_fd_sc_hd__clkdlybuf4s25_1
XFILLER_10_38 VGND VGND VDPWR VDPWR sky130_fd_sc_hd__fill_2
XPHY_EDGE_ROW_14_Right_14 VGND VGND VDPWR VDPWR sky130_fd_sc_hd__decap_3
X_071_ _071_/A VGND VGND VDPWR VDPWR _071_/Y sky130_fd_sc_hd__inv_2
X_140_ _192_/Q _150_/B VGND VGND VDPWR VDPWR _163_/A sky130_fd_sc_hd__nor2_2
XPHY_EDGE_ROW_4_Right_4 VGND VGND VDPWR VDPWR sky130_fd_sc_hd__decap_3
X_106_ smpb _117_/B VGND VGND VDPWR VDPWR gpb[4] sky130_fd_sc_hd__nand2_2
X_123_ _158_/A _172_/Q _174_/Q VGND VGND VDPWR VDPWR _123_/X sky130_fd_sc_hd__or3_2
Xfanout17 rst_n VGND VGND VDPWR VDPWR fanout17/X sky130_fd_sc_hd__clkdlybuf4s25_1
X_070_ _174_/Q VGND VGND VDPWR VDPWR _160_/B sky130_fd_sc_hd__inv_2
XPHY_EDGE_ROW_10_Left_25 VGND VGND VDPWR VDPWR sky130_fd_sc_hd__decap_3
X_122_ _158_/A _172_/Q VGND VGND VDPWR VDPWR _122_/Y sky130_fd_sc_hd__nor2_2
XTAP_TAPCELL_ROW_4_40 VGND VDPWR sky130_fd_sc_hd__tapvpwrvgnd_1
X_105_ _081_/B ui_in[4] _179_/Q _096_/X VGND VGND VDPWR VDPWR _117_/B sky130_fd_sc_hd__a22o_2
XFILLER_1_118 VGND VGND VDPWR VDPWR sky130_fd_sc_hd__fill_1
XFILLER_5_73 VGND VGND VDPWR VDPWR sky130_fd_sc_hd__fill_1
XTAP_TAPCELL_ROW_14_60 VGND VDPWR sky130_fd_sc_hd__tapvpwrvgnd_1
XFILLER_7_102 VGND VGND VDPWR VDPWR sky130_fd_sc_hd__fill_2
X_104_ smpb _116_/B VGND VGND VDPWR VDPWR gpb[3] sky130_fd_sc_hd__nand2_2
X_121_ _080_/S uio_in[2] _121_/B1 _096_/X VGND VGND VDPWR VDPWR cmp_clkb sky130_fd_sc_hd__a22oi_2
XFILLER_12_3 VGND VGND VDPWR VDPWR sky130_fd_sc_hd__fill_2
XTAP_TAPCELL_ROW_4_41 VGND VDPWR sky130_fd_sc_hd__tapvpwrvgnd_1
XFILLER_14_72 VGND VGND VDPWR VDPWR sky130_fd_sc_hd__decap_3
XFILLER_5_52 VGND VGND VDPWR VDPWR sky130_fd_sc_hd__decap_3
XFILLER_5_63 VGND VGND VDPWR VDPWR sky130_fd_sc_hd__fill_2
XTAP_TAPCELL_ROW_14_61 VGND VDPWR sky130_fd_sc_hd__tapvpwrvgnd_1
XPHY_EDGE_ROW_10_Right_10 VGND VGND VDPWR VDPWR sky130_fd_sc_hd__decap_3
X_120_ _120_/A _120_/B VGND VGND VDPWR VDPWR wire1/A sky130_fd_sc_hd__nor2_2
X_197_ uio_in[3] VGND VGND VDPWR VDPWR ref_sel sky130_fd_sc_hd__buf_2
XFILLER_8_52 VGND VGND VDPWR VDPWR sky130_fd_sc_hd__decap_3
X_103_ _079_/S ui_in[3] _178_/Q _096_/X VGND VGND VDPWR VDPWR _116_/B sky130_fd_sc_hd__a22o_2
XPHY_EDGE_ROW_8_Right_8 VGND VGND VDPWR VDPWR sky130_fd_sc_hd__decap_3
XTAP_TAPCELL_ROW_14_62 VGND VDPWR sky130_fd_sc_hd__tapvpwrvgnd_1
X_196_ _196_/CLK _196_/D fanout16/X VGND VGND VDPWR VDPWR _196_/Q sky130_fd_sc_hd__dfstp_2
XFILLER_2_3 VGND VGND VDPWR VDPWR sky130_fd_sc_hd__decap_3
XFILLER_7_126 VGND VGND VDPWR VDPWR sky130_fd_sc_hd__fill_1
X_102_ smpb _115_/B VGND VGND VDPWR VDPWR gpb[2] sky130_fd_sc_hd__nand2_2
Xclkbuf_2_2__f_clk clkbuf_0_clk/X VGND VGND VDPWR VDPWR _195_/CLK sky130_fd_sc_hd__clkbuf_16
X_179_ _189_/CLK _179_/D fanout15/X VGND VGND VDPWR VDPWR _179_/Q sky130_fd_sc_hd__dfrtp_2
XPHY_EDGE_ROW_14_Left_29 VGND VGND VDPWR VDPWR sky130_fd_sc_hd__decap_3
XTAP_TAPCELL_ROW_14_63 VGND VDPWR sky130_fd_sc_hd__tapvpwrvgnd_1
XPHY_EDGE_ROW_2_Left_17 VGND VGND VDPWR VDPWR sky130_fd_sc_hd__decap_3
X_195_ _195_/CLK _195_/D fanout16/X VGND VGND VDPWR VDPWR _195_/Q sky130_fd_sc_hd__dfrtp_2
XPHY_EDGE_ROW_5_Left_20 VGND VGND VDPWR VDPWR sky130_fd_sc_hd__decap_3
X_101_ _081_/B ui_in[2] _177_/Q _096_/X VGND VGND VDPWR VDPWR _115_/B sky130_fd_sc_hd__a22o_2
X_178_ _181_/CLK _178_/D fanout15/X VGND VGND VDPWR VDPWR _178_/Q sky130_fd_sc_hd__dfrtp_2
XFILLER_5_55 VGND VGND VDPWR VDPWR sky130_fd_sc_hd__fill_1
XTAP_TAPCELL_ROW_1_34 VGND VDPWR sky130_fd_sc_hd__tapvpwrvgnd_1
Xwire1 wire1/A VGND VGND VDPWR VDPWR gn[7] sky130_fd_sc_hd__clkbuf_4
X_194_ _194_/CLK _194_/D fanout17/X VGND VGND VDPWR VDPWR _194_/Q sky130_fd_sc_hd__dfrtp_2
XFILLER_11_87 VGND VGND VDPWR VDPWR sky130_fd_sc_hd__fill_1
XTAP_TAPCELL_ROW_11_54 VGND VDPWR sky130_fd_sc_hd__tapvpwrvgnd_1
X_100_ smpb _114_/B VGND VGND VDPWR VDPWR gpb[1] sky130_fd_sc_hd__nand2_2
X_177_ _194_/CLK _177_/D fanout16/X VGND VGND VDPWR VDPWR _177_/Q sky130_fd_sc_hd__dfrtp_2
XFILLER_8_55 VGND VGND VDPWR VDPWR sky130_fd_sc_hd__fill_1
Xu_drv.u_lqb onb _071_/A VGND VGND VDPWR VDPWR u_drv.u_lq/B sky130_fd_sc_hd__nand2_1
XTAP_TAPCELL_ROW_1_35 VGND VDPWR sky130_fd_sc_hd__tapvpwrvgnd_1
XFILLER_2_6 VGND VGND VDPWR VDPWR sky130_fd_sc_hd__fill_1
XTAP_TAPCELL_ROW_11_55 VGND VDPWR sky130_fd_sc_hd__tapvpwrvgnd_1
Xwire2 wire2/A VGND VGND VDPWR VDPWR gn[6] sky130_fd_sc_hd__clkbuf_4
X_193_ _195_/CLK _193_/D fanout16/X VGND VGND VDPWR VDPWR _193_/Q sky130_fd_sc_hd__dfrtp_2
XFILLER_11_125 VGND VGND VDPWR VDPWR sky130_fd_sc_hd__fill_2
X_176_ _181_/CLK _176_/D fanout15/X VGND VGND VDPWR VDPWR _176_/Q sky130_fd_sc_hd__dfrtp_2
X_159_ hold41/X _141_/Y _158_/X _152_/X _146_/D VGND VGND VDPWR VDPWR _180_/D sky130_fd_sc_hd__a32o_2
XFILLER_0_113 VGND VGND VDPWR VDPWR sky130_fd_sc_hd__fill_1
XFILLER_14_55 VGND VGND VDPWR VDPWR sky130_fd_sc_hd__fill_1
Xwire3 wire3/A VGND VGND VDPWR VDPWR gn[5] sky130_fd_sc_hd__clkbuf_4
X_192_ _195_/CLK _192_/D fanout16/X VGND VGND VDPWR VDPWR _192_/Q sky130_fd_sc_hd__dfrtp_2
XTAP_TAPCELL_ROW_7_46 VGND VDPWR sky130_fd_sc_hd__tapvpwrvgnd_1
X_175_ _195_/CLK _175_/D fanout16/X VGND VGND VDPWR VDPWR _175_/Q sky130_fd_sc_hd__dfrtp_2
XPHY_EDGE_ROW_9_Left_24 VGND VGND VDPWR VDPWR sky130_fd_sc_hd__decap_3
X_089_ enb[2] VGND VGND VDPWR VDPWR en[2] sky130_fd_sc_hd__inv_2
X_158_ _158_/A _158_/B _160_/B _160_/C VGND VGND VDPWR VDPWR _158_/X sky130_fd_sc_hd__or4_2
XPHY_EDGE_ROW_3_Right_3 VGND VGND VDPWR VDPWR sky130_fd_sc_hd__decap_3
Xwire4 wire4/A VGND VGND VDPWR VDPWR gn[4] sky130_fd_sc_hd__clkbuf_4
X_191_ _195_/CLK _191_/D fanout16/X VGND VGND VDPWR VDPWR _191_/Q sky130_fd_sc_hd__dfstp_2
XTAP_TAPCELL_ROW_7_47 VGND VDPWR sky130_fd_sc_hd__tapvpwrvgnd_1
X_088_ uio_in[6] uio_in[7] VGND VGND VDPWR VDPWR enb[2] sky130_fd_sc_hd__nand2b_2
X_174_ _181_/CLK _174_/D fanout15/X VGND VGND VDPWR VDPWR _174_/Q sky130_fd_sc_hd__dfstp_2
X_157_ _155_/X _156_/X _141_/Y VGND VGND VDPWR VDPWR _179_/D sky130_fd_sc_hd__o21a_2
XFILLER_5_26 VGND VGND VDPWR VDPWR sky130_fd_sc_hd__decap_3
XPHY_EDGE_ROW_13_Right_13 VGND VGND VDPWR VDPWR sky130_fd_sc_hd__decap_3
Xwire5 wire5/A VGND VGND VDPWR VDPWR gn[3] sky130_fd_sc_hd__clkbuf_4
XFILLER_14_125 VGND VGND VDPWR VDPWR sky130_fd_sc_hd__fill_2
XFILLER_2_38 VGND VGND VDPWR VDPWR sky130_fd_sc_hd__fill_2
X_190_ _194_/CLK _190_/D fanout17/X VGND VGND VDPWR VDPWR _190_/Q sky130_fd_sc_hd__dfrtp_2
X_173_ _181_/CLK _173_/D fanout15/X VGND VGND VDPWR VDPWR _173_/Q sky130_fd_sc_hd__dfstp_2
X_087_ enb[1] VGND VGND VDPWR VDPWR en[1] sky130_fd_sc_hd__inv_2
Xwire10 _071_/A VGND VGND VDPWR VDPWR cmp_out sky130_fd_sc_hd__clkbuf_4
X_156_ _173_/Q _160_/B _160_/C hold46/X VGND VGND VDPWR VDPWR _156_/X sky130_fd_sc_hd__o31a_2
XFILLER_14_69 VGND VGND VDPWR VDPWR sky130_fd_sc_hd__decap_3
X_139_ hold37/X _122_/Y _138_/Y VGND VGND VDPWR VDPWR _139_/Y sky130_fd_sc_hd__a21oi_2
Xclkbuf_2_3__f_clk clkbuf_0_clk/X VGND VGND VDPWR VDPWR _194_/CLK sky130_fd_sc_hd__clkbuf_16
Xwire6 wire6/A VGND VGND VDPWR VDPWR gn[2] sky130_fd_sc_hd__clkbuf_4
X_086_ uio_in[7] uio_in[6] VGND VGND VDPWR VDPWR enb[1] sky130_fd_sc_hd__nand2b_2
X_155_ _158_/A _172_/Q _174_/Q _155_/D VGND VGND VDPWR VDPWR _155_/X sky130_fd_sc_hd__and4b_2
X_172_ _181_/CLK _172_/D fanout15/X VGND VGND VDPWR VDPWR _172_/Q sky130_fd_sc_hd__dfstp_2
XFILLER_0_94 VGND VGND VDPWR VDPWR sky130_fd_sc_hd__fill_1
X_069_ _172_/Q VGND VGND VDPWR VDPWR _158_/B sky130_fd_sc_hd__inv_2
X_138_ _193_/Q _141_/A _174_/Q VGND VGND VDPWR VDPWR _138_/Y sky130_fd_sc_hd__a21oi_2
XPHY_EDGE_ROW_7_Right_7 VGND VGND VDPWR VDPWR sky130_fd_sc_hd__decap_3
Xwire7 wire7/A VGND VGND VDPWR VDPWR gn[1] sky130_fd_sc_hd__clkbuf_4
X_171_ _182_/Q hold26/X _171_/S VGND VGND VDPWR VDPWR _171_/X sky130_fd_sc_hd__mux2_1
X_085_ enb[0] VGND VGND VDPWR VDPWR en[0] sky130_fd_sc_hd__inv_2
X_154_ hold40/X _141_/Y _153_/X _152_/X _122_/Y VGND VGND VDPWR VDPWR _178_/D sky130_fd_sc_hd__a32o_2
XPHY_EDGE_ROW_13_Left_28 VGND VGND VDPWR VDPWR sky130_fd_sc_hd__decap_3
X_137_ _141_/A _122_/Y _134_/X _132_/X _158_/A VGND VGND VDPWR VDPWR _173_/D sky130_fd_sc_hd__o32a_2
Xwire8 wire8/A VGND VGND VDPWR VDPWR gn[0] sky130_fd_sc_hd__clkbuf_4
XFILLER_9_110 VGND VGND VDPWR VDPWR sky130_fd_sc_hd__fill_2
XPHY_EDGE_ROW_1_Left_16 VGND VGND VDPWR VDPWR sky130_fd_sc_hd__decap_3
X_170_ _181_/Q hold30/X _171_/S VGND VGND VDPWR VDPWR _170_/X sky130_fd_sc_hd__mux2_1
X_067_ _177_/Q VGND VGND VDPWR VDPWR _067_/Y sky130_fd_sc_hd__inv_2
X_084_ uio_in[7] uio_in[6] VGND VGND VDPWR VDPWR enb[0] sky130_fd_sc_hd__or2_2
X_136_ _172_/Q _173_/Q VGND VGND VDPWR VDPWR _146_/D sky130_fd_sc_hd__and2b_2
X_153_ _174_/Q _153_/B _160_/C VGND VGND VDPWR VDPWR _153_/X sky130_fd_sc_hd__or3_2
X_119_ _120_/A _119_/B VGND VGND VDPWR VDPWR wire2/A sky130_fd_sc_hd__nor2_1
XFILLER_7_3 VGND VGND VDPWR VDPWR sky130_fd_sc_hd__fill_2
X_083_ _193_/Q _192_/Q VGND VGND VDPWR VDPWR _196_/D sky130_fd_sc_hd__nor2_2
X_152_ _192_/Q _174_/Q _155_/D VGND VGND VDPWR VDPWR _152_/X sky130_fd_sc_hd__and3_2
XFILLER_0_75 VGND VGND VDPWR VDPWR sky130_fd_sc_hd__fill_2
X_066_ _192_/Q VGND VGND VDPWR VDPWR _141_/A sky130_fd_sc_hd__inv_2
X_118_ _120_/A _118_/B VGND VGND VDPWR VDPWR wire3/A sky130_fd_sc_hd__nor2_2
X_135_ _158_/A _172_/Q VGND VGND VDPWR VDPWR _153_/B sky130_fd_sc_hd__nand2_2
X_082_ _080_/S _196_/Q _081_/Y VGND VGND VDPWR VDPWR smpt sky130_fd_sc_hd__o21a_2
X_134_ _158_/A _172_/Q VGND VGND VDPWR VDPWR _134_/X sky130_fd_sc_hd__and2_2
X_151_ _149_/X _150_/X _163_/A VGND VGND VDPWR VDPWR _177_/D sky130_fd_sc_hd__a21oi_2
XTAP_TAPCELL_ROW_5_42 VGND VDPWR sky130_fd_sc_hd__tapvpwrvgnd_1
X_117_ _120_/A _117_/B VGND VGND VDPWR VDPWR wire4/A sky130_fd_sc_hd__nor2_2
X_081_ uio_in[1] _081_/B VGND VGND VDPWR VDPWR _081_/Y sky130_fd_sc_hd__nand2b_2
X_150_ _174_/Q _150_/B _153_/B VGND VGND VDPWR VDPWR _150_/X sky130_fd_sc_hd__or3_2
XPHY_EDGE_ROW_8_Left_23 VGND VGND VDPWR VDPWR sky130_fd_sc_hd__decap_3
X_133_ _141_/A _132_/X _158_/B VGND VGND VDPWR VDPWR _172_/D sky130_fd_sc_hd__mux2_1
XPHY_EDGE_ROW_2_Right_2 VGND VGND VDPWR VDPWR sky130_fd_sc_hd__decap_3
XTAP_TAPCELL_ROW_5_43 VGND VDPWR sky130_fd_sc_hd__tapvpwrvgnd_1
X_116_ _120_/A _116_/B VGND VGND VDPWR VDPWR wire5/A sky130_fd_sc_hd__nor2_2
XFILLER_12_53 VGND VGND VDPWR VDPWR sky130_fd_sc_hd__decap_3
XFILLER_5_3 VGND VGND VDPWR VDPWR sky130_fd_sc_hd__fill_2
X_080_ _190_/Q ui_in[7] _080_/S VGND VGND VDPWR VDPWR uo_out[7] sky130_fd_sc_hd__mux2_1
X_132_ _196_/D _171_/S VGND VGND VDPWR VDPWR _132_/X sky130_fd_sc_hd__and2b_2
X_115_ _120_/A _115_/B VGND VGND VDPWR VDPWR wire6/A sky130_fd_sc_hd__nor2_2
Xhold40 _178_/Q VGND VGND VDPWR VDPWR hold40/X sky130_fd_sc_hd__dlygate4sd3_1
.ends
