* LVS reference for the M1 top level (generated by layout/m1_top.py)
.subckt bias_gen VDPWR VGND pd nbias pbias
*.iopin VDPWR
*.iopin VGND
*.ipin pd
*.opin nbias
*.opin pbias
XMP1 nbias pbias VDPWR VDPWR sky130_fd_pr__pfet_01v8_lvt L=2 W=2 nf=1 ad=0.58 as=0.58 pd=4.58 ps=4.58 nrd=0.145 nrs=0.145 sa=0
+ sb=0 sd=0 mult=1
XMP2 pbias pbias VDPWR VDPWR sky130_fd_pr__pfet_01v8_lvt L=2 W=2 nf=1 ad=0.58 as=0.58 pd=4.58 ps=4.58 nrd=0.145 nrs=0.145 sa=0
+ sb=0 sd=0 mult=1
XMN1 nbias nbias VGND VGND sky130_fd_pr__nfet_01v8 L=2 W=2 nf=1 ad=0.58 as=0.58 pd=4.58 ps=4.58 nrd=0.145 nrs=0.145 sa=0 sb=0 sd=0
+ mult=1
XMN2 pbias nbias nr VGND sky130_fd_pr__nfet_01v8 L=2 W=2 nf=1 ad=0.58 as=0.58 pd=4.58 ps=4.58 nrd=0.145 nrs=0.145 sa=0 sb=0 sd=0
+ mult=4 m=4
XR1A r1m nr VGND sky130_fd_pr__res_xhigh_po_0p35 L=5.45 mult=1
XR1B VGND r1m VGND sky130_fd_pr__res_xhigh_po_0p35 L=5.45 mult=1
XMDN1 VGND VGND VGND VGND sky130_fd_pr__nfet_01v8 L=2 W=2 nf=1 ad=0.58 as=0.58 pd=4.58 ps=4.58 nrd=0.145 nrs=0.145 sa=0 sb=0 sd=0
+ mult=1
XMDN2 VGND VGND VGND VGND sky130_fd_pr__nfet_01v8 L=2 W=2 nf=1 ad=0.58 as=0.58 pd=4.58 ps=4.58 nrd=0.145 nrs=0.145 sa=0 sb=0 sd=0
+ mult=1
XMDP1 VDPWR VDPWR VDPWR VDPWR sky130_fd_pr__pfet_01v8_lvt L=2 W=2 nf=1 ad=0.58 as=0.58 pd=4.58 ps=4.58 nrd=0.145 nrs=0.145 sa=0
+ sb=0 sd=0 mult=1
XMDP2 VDPWR VDPWR VDPWR VDPWR sky130_fd_pr__pfet_01v8_lvt L=2 W=2 nf=1 ad=0.58 as=0.58 pd=4.58 ps=4.58 nrd=0.145 nrs=0.145 sa=0
+ sb=0 sd=0 mult=1
XR1D1 VGND VGND VGND sky130_fd_pr__res_xhigh_po_0p35 L=5.45 mult=1
XR1D2 VGND VGND VGND sky130_fd_pr__res_xhigh_po_0p35 L=5.45 mult=1
XMS2A ms2_1 VGND sup VDPWR sky130_fd_pr__pfet_01v8 L=10 W=0.42 nf=1 ad=0.1218 as=0.1218 pd=1.42 ps=1.42 nrd=0.69047619047619
+ nrs=0.69047619047619 sa=0 sb=0 sd=0 mult=1
XMS2B su VGND ms2_1 VDPWR sky130_fd_pr__pfet_01v8 L=10 W=0.42 nf=1 ad=0.1218 as=0.1218 pd=1.42 ps=1.42 nrd=0.69047619047619
+ nrs=0.69047619047619 sa=0 sb=0 sd=0 mult=1
XMS3 su nbias VGND VGND sky130_fd_pr__nfet_01v8 L=2 W=4 nf=1 ad=1.16 as=1.16 pd=8.58 ps=8.58 nrd=0.0725 nrs=0.0725 sa=0 sb=0 sd=0
+ mult=1
XMS1 pbias su VGND VGND sky130_fd_pr__nfet_01v8 L=1 W=0.42 nf=1 ad=0.1218 as=0.1218 pd=1.42 ps=1.42 nrd=0.69047619047619
+ nrs=0.69047619047619 sa=0 sb=0 sd=0 mult=1
XMPD2 sup pd VDPWR VDPWR sky130_fd_pr__pfet_01v8 L=1 W=0.42 nf=1 ad=0.1218 as=0.1218 pd=1.42 ps=1.42 nrd=0.69047619047619
+ nrs=0.69047619047619 sa=0 sb=0 sd=0 mult=1
XMPD1 pbias pdb VDPWR VDPWR sky130_fd_pr__pfet_01v8 L=1 W=0.42 nf=1 ad=0.1218 as=0.1218 pd=1.42 ps=1.42 nrd=0.69047619047619
+ nrs=0.69047619047619 sa=0 sb=0 sd=0 mult=1
XMND1 nbias pd VGND VGND sky130_fd_pr__nfet_01v8 L=1 W=0.42 nf=1 ad=0.1218 as=0.1218 pd=1.42 ps=1.42 nrd=0.69047619047619
+ nrs=0.69047619047619 sa=0 sb=0 sd=0 mult=1
XMND2 su pd VGND VGND sky130_fd_pr__nfet_01v8 L=1 W=0.42 nf=1 ad=0.1218 as=0.1218 pd=1.42 ps=1.42 nrd=0.69047619047619
+ nrs=0.69047619047619 sa=0 sb=0 sd=0 mult=1
XMIP pdb pd VDPWR VDPWR sky130_fd_pr__pfet_01v8 L=1 W=0.84 nf=1 ad=0.2436 as=0.2436 pd=2.26 ps=2.26 nrd=0.345238095238095
+ nrs=0.345238095238095 sa=0 sb=0 sd=0 mult=1
XMIN pdb pd VGND VGND sky130_fd_pr__nfet_01v8 L=1 W=0.42 nf=1 ad=0.1218 as=0.1218 pd=1.42 ps=1.42 nrd=0.69047619047619
+ nrs=0.69047619047619 sa=0 sb=0 sd=0 mult=1
.ends
.subckt bandgap_core VDPWR VGND pbias pd vbg vgp
*.iopin VDPWR
*.iopin VGND
*.ipin pbias
*.ipin pd
*.opin vbg
*.opin vgp
XMDS1 VDPWR VDPWR VDPWR VDPWR sky130_fd_pr__pfet_01v8 L=1 W=16 nf=1 ad=4.64 as=4.64 pd=32.58 ps=32.58 nrd=0.018125 nrs=0.018125
+ sa=0 sb=0 sd=0 mult=1
XMDS2 VDPWR VDPWR VDPWR VDPWR sky130_fd_pr__pfet_01v8 L=1 W=16 nf=1 ad=4.64 as=4.64 pd=32.58 ps=32.58 nrd=0.018125 nrs=0.018125
+ sa=0 sb=0 sd=0 mult=1
XMPA va vgp VDPWR VDPWR sky130_fd_pr__pfet_01v8 L=8 W=16 nf=1 ad=4.64 as=4.64 pd=32.58 ps=32.58 nrd=0.018125 nrs=0.018125 sa=0
+ sb=0 sd=0 mult=1
XMPB vb vgp VDPWR VDPWR sky130_fd_pr__pfet_01v8 L=8 W=16 nf=1 ad=4.64 as=4.64 pd=32.58 ps=32.58 nrd=0.018125 nrs=0.018125 sa=0
+ sb=0 sd=0 mult=1
XMPC vbg vgp VDPWR VDPWR sky130_fd_pr__pfet_01v8 L=8 W=16 nf=1 ad=4.64 as=4.64 pd=32.58 ps=32.58 nrd=0.018125 nrs=0.018125 sa=0
+ sb=0 sd=0 mult=1
XQ1 VGND VGND va sky130_fd_pr__pnp_05v5_W3p40L3p40 m=1 mult=1
XR1_1 r1__1 vb VGND sky130_fd_pr__res_xhigh_po_0p69 L=4 mult=1
XR1_2 vq2 r1__1 VGND sky130_fd_pr__res_xhigh_po_0p69 L=4 mult=1
XQ2 VGND VGND vq2 sky130_fd_pr__pnp_05v5_W3p40L3p40 m=8 mult=8
XR2_1 r2__1 vbg VGND sky130_fd_pr__res_xhigh_po_0p69 L=4 mult=1
XR2_2 r2__2 r2__1 VGND sky130_fd_pr__res_xhigh_po_0p69 L=4 mult=1
XR2_3 r2__3 r2__2 VGND sky130_fd_pr__res_xhigh_po_0p69 L=4 mult=1
XR2_4 r2__4 r2__3 VGND sky130_fd_pr__res_xhigh_po_0p69 L=4 mult=1
XR2_5 r2__5 r2__4 VGND sky130_fd_pr__res_xhigh_po_0p69 L=4 mult=1
XR2_6 r2__6 r2__5 VGND sky130_fd_pr__res_xhigh_po_0p69 L=4 mult=1
XR2_7 r2__7 r2__6 VGND sky130_fd_pr__res_xhigh_po_0p69 L=4 mult=1
XR2_8 r2__8 r2__7 VGND sky130_fd_pr__res_xhigh_po_0p69 L=4 mult=1
XR2_9 r2__9 r2__8 VGND sky130_fd_pr__res_xhigh_po_0p69 L=4 mult=1
XR2_10 r2__10 r2__9 VGND sky130_fd_pr__res_xhigh_po_0p69 L=4 mult=1
XR2_11 r2__11 r2__10 VGND sky130_fd_pr__res_xhigh_po_0p69 L=4 mult=1
XR2_12 r2__12 r2__11 VGND sky130_fd_pr__res_xhigh_po_0p69 L=4 mult=1
XR2_13 r2__13 r2__12 VGND sky130_fd_pr__res_xhigh_po_0p69 L=4 mult=1
XR2_14 r2__14 r2__13 VGND sky130_fd_pr__res_xhigh_po_0p69 L=4 mult=1
XR2_15 r2__15 r2__14 VGND sky130_fd_pr__res_xhigh_po_0p69 L=4 mult=1
XR2_16 r2__16 r2__15 VGND sky130_fd_pr__res_xhigh_po_0p69 L=4 mult=1
XR2_17 r2__17 r2__16 VGND sky130_fd_pr__res_xhigh_po_0p69 L=4 mult=1
XR2_18 r2__18 r2__17 VGND sky130_fd_pr__res_xhigh_po_0p69 L=4 mult=1
XR2_19 vq3 r2__18 VGND sky130_fd_pr__res_xhigh_po_0p69 L=4 mult=1
XQ3 VGND VGND vq3 sky130_fd_pr__pnp_05v5_W3p40L3p40 m=1 mult=1
XQD VGND VGND VGND sky130_fd_pr__pnp_05v5_W3p40L3p40 m=2 mult=2
XRD1 VGND VGND VGND sky130_fd_pr__res_xhigh_po_0p69 L=4 mult=1
XRD2 VGND VGND VGND sky130_fd_pr__res_xhigh_po_0p69 L=4 mult=1
xota VDPWR VGND pbias pd vb va vgp ota
XMSU2 su pbias VDPWR VDPWR sky130_fd_pr__pfet_01v8_lvt L=2 W=2 nf=1 ad=0.58 as=0.58 pd=4.58 ps=4.58 nrd=0.145 nrs=0.145 sa=0 sb=0
+ sd=0 mult=1
XMSU3 su vbg VGND VGND sky130_fd_pr__nfet_01v8 L=1 W=1 nf=1 ad=0.29 as=0.29 pd=2.58 ps=2.58 nrd=0.29 nrs=0.29 sa=0 sb=0 sd=0
+ mult=1
XMSU1 vgp su VGND VGND sky130_fd_pr__nfet_01v8 L=4 W=0.42 nf=1 ad=0.1218 as=0.1218 pd=1.42 ps=1.42 nrd=0.69047619047619
+ nrs=0.69047619047619 sa=0 sb=0 sd=0 mult=1
XMSD su pd VGND VGND sky130_fd_pr__nfet_01v8 L=1 W=0.42 nf=1 ad=0.1218 as=0.1218 pd=1.42 ps=1.42 nrd=0.69047619047619
+ nrs=0.69047619047619 sa=0 sb=0 sd=0 mult=1
.ends
.subckt ota VDPWR VGND pbias pd inp inn out
*.iopin VDPWR
*.iopin VGND
*.ipin pbias
*.ipin pd
*.ipin inp
*.ipin inn
*.opin out
XM5 tail pbias VDPWR VDPWR sky130_fd_pr__pfet_01v8_lvt L=2 W=2 nf=1 ad=0.58 as=0.58 pd=4.58 ps=4.58 nrd=0.145 nrs=0.145 sa=0 sb=0
+ sd=0 mult=2 m=2
XM1 d1 inn tail VDPWR sky130_fd_pr__pfet_01v8_lvt L=8 W=32 nf=1 ad=9.28 as=9.28 pd=64.58 ps=64.58 nrd=0.0090625 nrs=0.0090625 sa=0
+ sb=0 sd=0 mult=1
XM2 out1 inp tail VDPWR sky130_fd_pr__pfet_01v8_lvt L=8 W=32 nf=1 ad=9.28 as=9.28 pd=64.58 ps=64.58 nrd=0.0090625 nrs=0.0090625
+ sa=0 sb=0 sd=0 mult=1
XM3 d1 d1 VGND VGND sky130_fd_pr__nfet_01v8 L=16 W=4 nf=1 ad=1.16 as=1.16 pd=8.58 ps=8.58 nrd=0.0725 nrs=0.0725 sa=0 sb=0 sd=0
+ mult=1
XM4 out1 d1 VGND VGND sky130_fd_pr__nfet_01v8 L=16 W=4 nf=1 ad=1.16 as=1.16 pd=8.58 ps=8.58 nrd=0.0725 nrs=0.0725 sa=0 sb=0 sd=0
+ mult=1
XM6 out out1 VGND VGND sky130_fd_pr__nfet_01v8 L=16 W=4 nf=1 ad=1.16 as=1.16 pd=8.58 ps=8.58 nrd=0.0725 nrs=0.0725 sa=0 sb=0 sd=0
+ mult=4 m=4
XM7 out pbias VDPWR VDPWR sky130_fd_pr__pfet_01v8_lvt L=2 W=2 nf=1 ad=0.58 as=0.58 pd=4.58 ps=4.58 nrd=0.145 nrs=0.145 sa=0 sb=0
+ sd=0 mult=4 m=4
XRZA rzm out1 VGND sky130_fd_pr__res_xhigh_po_0p35 L=10.45 mult=1
XRZB cz rzm VGND sky130_fd_pr__res_xhigh_po_0p35 L=10.45 mult=1
XRZD1 VGND VGND VGND sky130_fd_pr__res_xhigh_po_0p35 L=10.45 mult=1
XRZD2 VGND VGND VGND sky130_fd_pr__res_xhigh_po_0p35 L=10.45 mult=1
XCC cz out sky130_fd_pr__cap_mim_m3_1 W=16 L=16 MF=4 m=4
XMDP1 VDPWR VDPWR VDPWR VDPWR sky130_fd_pr__pfet_01v8_lvt L=1 W=16 nf=1 ad=4.64 as=4.64 pd=32.58 ps=32.58 nrd=0.018125
+ nrs=0.018125 sa=0 sb=0 sd=0 mult=1
XMDP2 VDPWR VDPWR VDPWR VDPWR sky130_fd_pr__pfet_01v8_lvt L=1 W=16 nf=1 ad=4.64 as=4.64 pd=32.58 ps=32.58 nrd=0.018125
+ nrs=0.018125 sa=0 sb=0 sd=0 mult=1
XMPD out pdb VDPWR VDPWR sky130_fd_pr__pfet_01v8 L=1 W=0.42 nf=1 ad=0.1218 as=0.1218 pd=1.42 ps=1.42 nrd=0.69047619047619
+ nrs=0.69047619047619 sa=0 sb=0 sd=0 mult=1
XMND out1 pd VGND VGND sky130_fd_pr__nfet_01v8 L=1 W=0.42 nf=1 ad=0.1218 as=0.1218 pd=1.42 ps=1.42 nrd=0.69047619047619
+ nrs=0.69047619047619 sa=0 sb=0 sd=0 mult=1
XMIP pdb pd VDPWR VDPWR sky130_fd_pr__pfet_01v8 L=1 W=0.84 nf=1 ad=0.2436 as=0.2436 pd=2.26 ps=2.26 nrd=0.345238095238095
+ nrs=0.345238095238095 sa=0 sb=0 sd=0 mult=1
XMIN pdb pd VGND VGND sky130_fd_pr__nfet_01v8 L=1 W=0.42 nf=1 ad=0.1218 as=0.1218 pd=1.42 ps=1.42 nrd=0.69047619047619
+ nrs=0.69047619047619 sa=0 sb=0 sd=0 mult=1
.ends
.subckt vref_filt VGND vbg vbg_f
*.iopin VGND
*.ipin vbg
*.opin vbg_f
XRF_1 rf_1 vbg VGND sky130_fd_pr__res_xhigh_po_0p35 L=20 mult=1
XRF_2 rf_2 rf_1 VGND sky130_fd_pr__res_xhigh_po_0p35 L=20 mult=1
XRF_3 rf_3 rf_2 VGND sky130_fd_pr__res_xhigh_po_0p35 L=20 mult=1
XRF_4 rf_4 rf_3 VGND sky130_fd_pr__res_xhigh_po_0p35 L=20 mult=1
XRF_5 rf_5 rf_4 VGND sky130_fd_pr__res_xhigh_po_0p35 L=20 mult=1
XRF_6 rf_6 rf_5 VGND sky130_fd_pr__res_xhigh_po_0p35 L=20 mult=1
XRF_7 rf_7 rf_6 VGND sky130_fd_pr__res_xhigh_po_0p35 L=20 mult=1
XRF_8 rf_8 rf_7 VGND sky130_fd_pr__res_xhigh_po_0p35 L=20 mult=1
XRF_9 rf_9 rf_8 VGND sky130_fd_pr__res_xhigh_po_0p35 L=20 mult=1
XRF_10 rf_10 rf_9 VGND sky130_fd_pr__res_xhigh_po_0p35 L=20 mult=1
XRF_11 rf_11 rf_10 VGND sky130_fd_pr__res_xhigh_po_0p35 L=20 mult=1
XRF_12 rf_12 rf_11 VGND sky130_fd_pr__res_xhigh_po_0p35 L=20 mult=1
XRF_13 rf_13 rf_12 VGND sky130_fd_pr__res_xhigh_po_0p35 L=20 mult=1
XRF_14 vbg_f rf_13 VGND sky130_fd_pr__res_xhigh_po_0p35 L=20 mult=1
XRFD1 VGND VGND VGND sky130_fd_pr__res_xhigh_po_0p35 L=20 mult=1
XRFD2 VGND VGND VGND sky130_fd_pr__res_xhigh_po_0p35 L=20 mult=1
XMCF VGND vbg_f VGND VGND sky130_fd_pr__nfet_01v8 L=10 W=10 nf=1 ad=2.9 as=2.9 pd=20.58 ps=20.58 nrd=0.029 nrs=0.029 sa=0 sb=0
+ sd=0 mult=7 m=7
XCM vbg_f VGND sky130_fd_pr__cap_mim_m3_1 W=21 L=30 MF=2 m=2
.ends
.subckt ptat_out VDPWR VGND vgp vptat
*.iopin VDPWR
*.iopin VGND
*.ipin vgp
*.opin vptat
XR3D1 VGND VGND VGND sky130_fd_pr__res_xhigh_po_0p69 L=4 mult=1
XR3D2 VGND VGND VGND sky130_fd_pr__res_xhigh_po_0p69 L=4 mult=1
XMPP vptat vgp VDPWR VDPWR sky130_fd_pr__pfet_01v8 L=8 W=16 nf=1 ad=4.64 as=4.64 pd=32.58 ps=32.58 nrd=0.018125 nrs=0.018125 sa=0
+ sb=0 sd=0 mult=1
XR3_1 r3_1 vptat VGND sky130_fd_pr__res_xhigh_po_0p69 L=4 mult=1
XR3_2 r3_2 r3_1 VGND sky130_fd_pr__res_xhigh_po_0p69 L=4 mult=1
XR3_3 r3_3 r3_2 VGND sky130_fd_pr__res_xhigh_po_0p69 L=4 mult=1
XR3_4 r3_4 r3_3 VGND sky130_fd_pr__res_xhigh_po_0p69 L=4 mult=1
XR3_5 r3_5 r3_4 VGND sky130_fd_pr__res_xhigh_po_0p69 L=4 mult=1
XR3_6 r3_6 r3_5 VGND sky130_fd_pr__res_xhigh_po_0p69 L=4 mult=1
XR3_7 r3_7 r3_6 VGND sky130_fd_pr__res_xhigh_po_0p69 L=4 mult=1
XR3_8 r3_8 r3_7 VGND sky130_fd_pr__res_xhigh_po_0p69 L=4 mult=1
XR3_9 r3_9 r3_8 VGND sky130_fd_pr__res_xhigh_po_0p69 L=4 mult=1
XR3_10 r3_10 r3_9 VGND sky130_fd_pr__res_xhigh_po_0p69 L=4 mult=1
XR3_11 r3_11 r3_10 VGND sky130_fd_pr__res_xhigh_po_0p69 L=4 mult=1
XR3_12 r3_12 r3_11 VGND sky130_fd_pr__res_xhigh_po_0p69 L=4 mult=1
XR3_13 r3_13 r3_12 VGND sky130_fd_pr__res_xhigh_po_0p69 L=4 mult=1
XR3_14 r3_14 r3_13 VGND sky130_fd_pr__res_xhigh_po_0p69 L=4 mult=1
XR3_15 r3_15 r3_14 VGND sky130_fd_pr__res_xhigh_po_0p69 L=4 mult=1
XR3_16 r3_16 r3_15 VGND sky130_fd_pr__res_xhigh_po_0p69 L=4 mult=1
XR3_17 r3_17 r3_16 VGND sky130_fd_pr__res_xhigh_po_0p69 L=4 mult=1
XR3_18 r3_18 r3_17 VGND sky130_fd_pr__res_xhigh_po_0p69 L=4 mult=1
XR3_19 r3_19 r3_18 VGND sky130_fd_pr__res_xhigh_po_0p69 L=4 mult=1
XR3_20 r3_20 r3_19 VGND sky130_fd_pr__res_xhigh_po_0p69 L=4 mult=1
XR3_21 r3_21 r3_20 VGND sky130_fd_pr__res_xhigh_po_0p69 L=4 mult=1
XR3_22 VGND r3_21 VGND sky130_fd_pr__res_xhigh_po_0p69 L=4 mult=1
.ends
.subckt vref_sel VDPWR VGND ref_sel vref_oe bg_pd vref pad en_buf
*.iopin VDPWR
*.iopin VGND
*.ipin ref_sel
*.ipin vref_oe
*.ipin bg_pd
*.opin en_buf
*.iopin vref
*.iopin pad
XMP1A nb1 ref_sel VDPWR VDPWR sky130_fd_pr__pfet_01v8 L=1 W=1.68 nf=1 ad=0.4872 as=0.4872 pd=3.94 ps=3.94 nrd=0.172619047619048
+ nrs=0.172619047619048 sa=0 sb=0 sd=0 mult=1
XMP1B en_buf bg_pd nb1 VDPWR sky130_fd_pr__pfet_01v8 L=1 W=1.68 nf=1 ad=0.4872 as=0.4872 pd=3.94 ps=3.94 nrd=0.172619047619048
+ nrs=0.172619047619048 sa=0 sb=0 sd=0 mult=1
XMN1A en_buf ref_sel VGND VGND sky130_fd_pr__nfet_01v8 L=1 W=0.42 nf=1 ad=0.1218 as=0.1218 pd=1.42 ps=1.42 nrd=0.69047619047619
+ nrs=0.69047619047619 sa=0 sb=0 sd=0 mult=1
XMN1B en_buf bg_pd VGND VGND sky130_fd_pr__nfet_01v8 L=1 W=0.42 nf=1 ad=0.1218 as=0.1218 pd=1.42 ps=1.42 nrd=0.69047619047619
+ nrs=0.69047619047619 sa=0 sb=0 sd=0 mult=1
XMP2A nb2 ref_sel VDPWR VDPWR sky130_fd_pr__pfet_01v8 L=1 W=1.68 nf=1 ad=0.4872 as=0.4872 pd=3.94 ps=3.94 nrd=0.172619047619048
+ nrs=0.172619047619048 sa=0 sb=0 sd=0 mult=1
XMP2B en_pad_b vref_oe nb2 VDPWR sky130_fd_pr__pfet_01v8 L=1 W=1.68 nf=1 ad=0.4872 as=0.4872 pd=3.94 ps=3.94 nrd=0.172619047619048
+ nrs=0.172619047619048 sa=0 sb=0 sd=0 mult=1
XMN2A en_pad_b ref_sel VGND VGND sky130_fd_pr__nfet_01v8 L=1 W=0.42 nf=1 ad=0.1218 as=0.1218 pd=1.42 ps=1.42 nrd=0.69047619047619
+ nrs=0.69047619047619 sa=0 sb=0 sd=0 mult=1
XMN2B en_pad_b vref_oe VGND VGND sky130_fd_pr__nfet_01v8 L=1 W=0.42 nf=1 ad=0.1218 as=0.1218 pd=1.42 ps=1.42 nrd=0.69047619047619
+ nrs=0.69047619047619 sa=0 sb=0 sd=0 mult=1
XMP3 en_pad en_pad_b VDPWR VDPWR sky130_fd_pr__pfet_01v8 L=1 W=0.84 nf=1 ad=0.2436 as=0.2436 pd=2.26 ps=2.26 nrd=0.345238095238095
+ nrs=0.345238095238095 sa=0 sb=0 sd=0 mult=1
XMN3 en_pad en_pad_b VGND VGND sky130_fd_pr__nfet_01v8 L=1 W=0.42 nf=1 ad=0.1218 as=0.1218 pd=1.42 ps=1.42 nrd=0.69047619047619
+ nrs=0.69047619047619 sa=0 sb=0 sd=0 mult=1
XMTGN pad en_pad vref VGND sky130_fd_pr__nfet_01v8 L=0.15 W=10 nf=1 ad=2.9 as=2.9 pd=20.58 ps=20.58 nrd=0.029 nrs=0.029 sa=0 sb=0
+ sd=0 mult=1
XMTGP pad en_pad_b vref VDPWR sky130_fd_pr__pfet_01v8_lvt L=0.35 W=20 nf=1 ad=5.8 as=5.8 pd=40.58 ps=40.58 nrd=0.0145 nrs=0.0145
+ sa=0 sb=0 sd=0 mult=1
.ends
.subckt vref_buf VDPWR VGND nbias en in vref
*.iopin VDPWR
*.iopin VGND
*.ipin nbias
*.ipin en
*.ipin in
*.opin vref
XMT tail_sw nbias VGND VGND sky130_fd_pr__nfet_01v8 L=2 W=8 nf=1 ad=2.32 as=2.32 pd=16.58 ps=16.58 nrd=0.03625 nrs=0.03625 sa=0
+ sb=0 sd=0 mult=2 m=2
XMSW tail en tail_sw VGND sky130_fd_pr__nfet_01v8 L=0.15 W=4 nf=1 ad=1.16 as=1.16 pd=8.58 ps=8.58 nrd=0.0725 nrs=0.0725 sa=0 sb=0
+ sd=0 mult=1
XM1 dm in tail VGND sky130_fd_pr__nfet_01v8 L=1 W=4 nf=1 ad=1.16 as=1.16 pd=8.58 ps=8.58 nrd=0.0725 nrs=0.0725 sa=0 sb=0 sd=0
+ mult=1
XM2 vref vref tail VGND sky130_fd_pr__nfet_01v8 L=1 W=4 nf=1 ad=1.16 as=1.16 pd=8.58 ps=8.58 nrd=0.0725 nrs=0.0725 sa=0 sb=0 sd=0
+ mult=1
XM3 dm dm VDPWR VDPWR sky130_fd_pr__pfet_01v8_lvt L=1 W=4 nf=1 ad=1.16 as=1.16 pd=8.58 ps=8.58 nrd=0.0725 nrs=0.0725 sa=0 sb=0
+ sd=0 mult=1
XM4 vref dm VDPWR VDPWR sky130_fd_pr__pfet_01v8_lvt L=1 W=4 nf=1 ad=1.16 as=1.16 pd=8.58 ps=8.58 nrd=0.0725 nrs=0.0725 sa=0 sb=0
+ sd=0 mult=1
XMPU dm en VDPWR VDPWR sky130_fd_pr__pfet_01v8 L=1 W=0.42 nf=1 ad=0.1218 as=0.1218 pd=1.42 ps=1.42 nrd=0.69047619047619
+ nrs=0.69047619047619 sa=0 sb=0 sd=0 mult=1
XMCRES VGND vref VGND VGND sky130_fd_pr__nfet_01v8 L=10 W=10 nf=1 ad=2.9 as=2.9 pd=20.58 ps=20.58 nrd=0.029 nrs=0.029 sa=0 sb=0
+ sd=0 mult=7 m=7
.ends

.subckt tt_um_chiranjitpatel_sar_adc VDPWR VGND ui_in[3] ui_in[1] uio_in[3] ua[1]
xb VDPWR VGND ui_in[3] nbias pbias bias_gen
xbg VDPWR VGND pbias ui_in[3] vbg vgp bandgap_core
xpt VDPWR VGND vgp vptat ptat_out
xf VGND vbg vbg_f vref_filt
xbuf VDPWR VGND nbias en_buf vbg_f vref vref_buf
xsel VDPWR VGND uio_in[3] ui_in[1] ui_in[3] vref ua[1] en_buf vref_sel
.ends
